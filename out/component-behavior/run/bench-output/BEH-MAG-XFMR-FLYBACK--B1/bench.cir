B1 DCM flyback converter, ideal switch, XFMR_SAT magnetics (Lp=100u, N=Ns/Np=0.5, Llk=10n, small winding R). Generic example values (ASSUMED, not a specific datasheet part)
* v2 (REPIN-001): fb1_vout removed from print; its meas line already prints it once.
* v2: meas renamed fb1_* and printed as scalars (circuit unchanged)
* Expected (energy balance, lossless): Vout = Vin*D*sqrt(R/(2*Lp*f)) = 48*0.2*sqrt(100/(2*100u*100k)) = 21.466 V (a few % lower with Vf and winding loss)
* DCM check: Ipk = Vin*D/(Lp*f) = 0.96 A ; t_demag = Lp*Ipk*N/Vout = 2.2 us < (1-D)T = 8 us
* OHMNI BEH-MAG-XFMR models (behavioural_approximation). Pins: p1 p2 s1 s2 (p1 and s1 are dot terminals).
* LP = primary open-circuit inductance, N = Ns/Np, LLK = leakage seen at primary with secondary shorted.
* RP, RS winding DC resistances. CIW = interwinding capacitance (one lumped C p1-s1 / p2-s2 split).
* Linear coupled-inductor version (K element).
.subckt XFMR_K p1 p2 s1 s2 LP=1m N=1 LLK=1u RP=1m RS=1m CIW=1p
.param kk={sqrt(1-LLK/LP)}
Rp1 p1 pa {RP}
L1 pa p2 {LP}
L2 sa s2 {LP*N*N}
Rs1 s1 sa {RS}
K12 L1 L2 {kk}
Ciw1 p1 s1 {CIW/2}
Ciw2 p2 s2 {CIW/2}
.ends

* Saturating version: leakage Llk in series on primary side, nonlinear magnetizing inductance across an ideal transformer.
* ISATM = magnetizing current at which Lm has dropped by DROP (referred to primary). LR = Lsat/Lm floor.
.subckt XFMR_SAT p1 p2 s1 s2 LP=1m N=1 LLK=1u RP=1m RS=1m CIW=1p ISATM=1 DROP=0.3 LR=0.05
.param lmag={LP-LLK}
.param ia={ISATM/atanh(sqrt(DROP/(1-LR)))}
Rp1 p1 pa {RP}
Llk pa pb {LLK}
Lm pb p2 L='lmag*(LR+(1-LR)*(1/cosh(max(min(i(Lm)/ia,20),-20)))**2)'
* ideal transformer v(sx,s2)=N*v(pb,p2); current N*i(Vs) forced pb->p2
Es sx s2 pb p2 {N}
Vs sx sb 0
Fp pb p2 Vs {N}
Rs1 s1 sb {RS}
Ciw1 p1 s1 {CIW/2}
Ciw2 p2 s2 {CIW/2}
.ends

.model SW SW(Ron=5m Roff=1G Vt=2.5 Vh=0.1)
.model DSCH D(IS=1e-7 N=1.05 RS=20m CJO=50p)
Vin in 0 DC 48
Vg g 0 PULSE(0 5 0 5n 5n 2u 10u)
* p1(dot)=in, p2=drain, s1(dot)=0 (output return), s2=diode anode. Dots: during on-time s2 is negative, diode blocks.
X1 in d 0 sa XFMR_SAT LP=100u N=0.5 LLK=10n RP=20m RS=40m CIW=10p ISATM=3 DROP=0.3 LR=0.05
S1 d 0 g 0 SW
D1 sa out DSCH
Co out 0 2.2u
RL out 0 100
.tran 100n 2.5m
.control
run
meas tran fb1_vout avg v(out) from=2m to=2.5m
meas tran fb1_ipk min i(Vin) from=2m to=2.5m
print fb1_ipk
quit
.endc
.end
