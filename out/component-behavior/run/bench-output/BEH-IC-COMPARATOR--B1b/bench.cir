* BEH-IC-COMPARATOR B1b: output saturation voltage. IN+ 0.5 V below IN-, 1.1k pull-up to 5 V.
* v2: scalars printed as 'name = value'; behavior unchanged
* Sink law: I = Isat*tanh(V/(Ron*Isat)), Isat=16 mA, Ron=33 ohm. Solve (5-V)/1100 = 0.016*tanh(V/0.528) -> V = 0.149 V at I = 4.4 mA.
* Datasheet (TI SLCS005AH extract): VOL typ 0.13 V (min col), max 0.4 V at IOL=4 mA. NOTE: op solve prints gmin/source-stepping warnings in ngspice 42 but converges.
* BEH-IC-COMPARATOR open-collector comparator macromodel (behavioural_approximation), LM393 numbers (TI SLCS005AH extract).
* pins: inp inm vcc gnd out   (one of two channels; package binding picks the channel pins)
* IN+ > IN- (+ offset): output transistor off (high-Z, leakage ioh); IN+ < IN-: output sinks, Ron-limited with Isat.
* Response: dominant-pole node n1 (clamped to +-Vs) chases A*vd -> trips when it crosses 0: t = td + tau*ln(1+Vs/(A*vod)); calibrated to 1.3 us @5 mV overdrive and 0.3 us @ TTL step.
.subckt comp_oc inp inm vcc gnd out params: vos=2m ib=25n ios=3n ron=33 isat=16m a=200 vs=1 tau=1.44u td=0.3u icc=450u ioh=1n
Vos ip1 inp dc {vos}
Ibp vcc ip1 dc {ib+ios/2}
Ibm vcc inm dc {ib-ios/2}
Bt tgt gnd V=max(min({a}*(v(ip1)-v(inm)),100),-100)
* n1 integrates toward tgt with time constant tau but is held inside +-Vs (gate switches the charging current off smoothly at the limits)
Bn gnd n1 I=max(v(tgt)-v(n1),0)*0.5*(1-tanh((v(n1)-{vs})/0.01))+min(v(tgt)-v(n1),0)*0.5*(1+tanh((v(n1)+{vs})/0.01))
C1 n1 gnd {tau} ic=0
Rl1 n1 gnd 1e12
Rsd n1 d2 50
T1 d2 gnd d3 gnd Z0=50 TD={td}
Rtd d3 gnd 50
Bsh sh gnd V=2*v(d3)
* output sinks when sh < 0
Bout out gnd I=0.5*(1-tanh(v(sh)/0.02))*{isat}*tanh((v(out)-v(gnd))/({ron}*{isat}))+{ioh}
Icc vcc gnd dc {icc}
.ends

Vcc vcc 0 5
Vref ref 0 2.5
Vin in 0 2.0
X1 in ref vcc 0 out comp_oc
Rpu vcc out 1.1k
.control
set noaskquit
op
let vol = v(out)
let iol = (5-v(out))/1100*1000
echo vol_b1b_v = $&vol
echo iol_b1b_mA = $&iol
quit
.endc
.end
