* BEH-TRN-BJT B7: switching times of the fits, resistive load, compared with datasheet MAXIMA
* v2: absolute include path made relative; .meas results (printed with targ=/trig= fields) re-exported as td1_ns..tf2_ns scalars
* 2N3904 (2N3903/D Rev 9): td<=35 ns, tr<=35 ns, ts<=200 ns, tf<=50 ns at Vcc=3 V, Ic=10 mA
*   test deck: RL=275 ohm, Rb=3.3k, drive -1 V -> +4 V (IB1~1 mA, IB2~0.5 mA; ASSUMED drive, the datasheet drive circuit was not captured)
* PN2222A (PN2222A/D Rev 1.1.0): td 10 ns, tr 25 ns, ts 225 ns, tf 60 ns (quoted as limits; conditions not captured)
*   test deck: Vcc 30 V, RL 200 ohm (Ic~150 mA), Rb 200 ohm, drive -1 -> +4 V (ASSUMED)
* Expected: each time <= datasheet number. Tolerance: hard limit (model is a fit, not guaranteed typical)
* OHMNI R6 BJT models fitted to onsemi datasheet bands (see parts/R6.md, BEH-TRN-BJT section 4)
* fidelity: behavioural_approximation. NOT a vendor model. Basis: ngspice Gummel-Poon fit to
* hFE min/max bands, Vce(sat), Vbe(sat), fT (datasheet), Cobo/Cibo (datasheet); VAF, BR, TR, XTB, XTI, EG are ASSUMPTIONs.
.model Q2N3904_R6FIT NPN(IS=1.4693e-14 BF=325.03 NF=1 VAF=100 IKF=0.061592 ISE=2.5511e-14 NE=1.331 BR=4 NR=1 RB=12.769 RE=1.1905 RC=1 CJE=9.4e-12 VJE=0.75 MJE=0.33 CJC=6.7e-12 VJC=0.75 MJC=0.33 TF=4.775e-10 XTF=2 ITF=0.4 VTF=4 TR=5e-08 XTB=1.5 EG=1.11 XTI=3)
.model Q2N2222A_R6FIT NPN(IS=3.2019e-14 BF=558.78 NF=1 VAF=100 IKF=0.21803 ISE=2.7068e-14 NE=1.2366 BR=4 NR=1 RB=6.6976 RE=0.097874 RC=0.56613 CJE=29e-12 VJE=0.75 MJE=0.33 CJC=17e-12 VJC=0.75 MJC=0.33 TF=4.608e-10 XTF=2 ITF=0.5 VTF=4 TR=6e-8 XTB=1.5 EG=1.11 XTI=3)

Q1 c1 b1 0 Q2N3904_R6FIT
Vcc1 vcc1 0 3
RL1 vcc1 c1 275
Rb1 drv b1 3.3k
Q2 c2 b2 0 Q2N2222A_R6FIT
Vcc2 vcc2 0 30
RL2 vcc2 c2 200
Rb2 drv b2 200
Vd drv 0 pulse(-1 4 20n 1n 1n 400n 1.2u)
.tran 0.2n 900n
.control
set noaskquit
run
let i1=(3-v(c1))/275
let i2=(30-v(c2))/200
meas tran td1 trig v(drv) val=1.5 rise=1 targ i1 val=1m rise=1
meas tran tr1 trig i1 val=1m rise=1 targ i1 val=9m rise=1
meas tran ts1 trig v(drv) val=1.5 fall=1 targ i1 val=9m fall=1
meas tran tf1 trig i1 val=9m fall=1 targ i1 val=1m fall=1
meas tran td2 trig v(drv) val=1.5 rise=1 targ i2 val=15m rise=1
meas tran tr2 trig i2 val=15m rise=1 targ i2 val=135m rise=1
meas tran ts2 trig v(drv) val=1.5 fall=1 targ i2 val=135m fall=1
meas tran tf2 trig i2 val=135m fall=1 targ i2 val=15m fall=1
let td1_ns = td1*1e9
let tr1_ns = tr1*1e9
let ts1_ns = ts1*1e9
let tf1_ns = tf1*1e9
let td2_ns = td2*1e9
let tr2_ns = tr2*1e9
let ts2_ns = ts2*1e9
let tf2_ns = tf2*1e9
print td1_ns tr1_ns ts1_ns tf1_ns td2_ns tr2_ns ts2_ns tf2_ns
quit
.endc
.end
