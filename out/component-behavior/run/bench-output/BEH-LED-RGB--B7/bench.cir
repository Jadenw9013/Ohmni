* B7: PLCC-4 RGB common anode (ASMB-MTB0 pin map: 1=A, 2=Blue K, 3=Green K, 4=Red K) from a 5 V rail, current-limiting resistors in the cathodes
* v2: header only; ir/ig/ib already print as bare scalars
* OHMNI BEH-LED-INDICATOR D-model cards (behavioural_approximation, NOT vendor models)
* Extracted by /home/claude/behavior/tmp_R5_fit.py from Vishay datasheet table and chart points, see R5.md S2..S6
* TNOM=27 C. CJO values from datasheet Cj where given (red 30 pF @0V TLDR4400; green 50 pF TLHG5800); others ASSUMPTION.
.model LED_RED   D (IS=1.846e-16 N=2.0  RS=16.4 CJO=30p VJ=1.0 M=0.33 TT=0 BV=15 IBV=10u EG=2.2 XTI=3)
.model LED_GREEN D (IS=3.793e-18 N=2.38 RS=8.76 CJO=50p VJ=1.0 M=0.33 TT=0 BV=15 IBV=10u EG=2.8 XTI=3)
.model LED_BLUE  D (IS=7.641e-24 N=3.0  RS=6.28 CJO=60p VJ=1.0 M=0.33 TT=0 BV=5.5 IBV=10u EG=4.6 XTI=3)
.model LED_WHITE D (IS=1.247e-19 N=3.0  RS=6.3  CJO=60p VJ=1.0 M=0.33 TT=0 BV=5.5 IBV=10u EG=3.9 XTI=3)
* RGB package dies anchored on Broadcom ASMB-MTB0-0A3A2 typical VF at 20 mA (red 2.1 V, green 3.1 V, blue 3.1 V); N, RS assumed (S-ASSUMPTION)
.model LED_RGB_R D (IS=4.848e-18 N=2.0 RS=12  CJO=30p VJ=1.0 M=0.33 BV=5.5 IBV=10u EG=2.2 XTI=3)
.model LED_RGB_GB D (IS=4.526e-19 N=3.0 RS=6.3 CJO=60p VJ=1.0 M=0.33 BV=5.5 IBV=10u EG=4.0 XTI=3)

V5 vcc 0 5
* pin1 = common anode
DR vcc kr LED_RGB_R
DG vcc kg LED_RGB_GB
DB vcc kb LED_RGB_GB
RR kr 0 145
RG kg 0 95
RB kb 0 95
.control
op
let ir=v(kr)/145
let ig=v(kg)/95
let ib=v(kb)/95
print ir ig ib
.endc
.end
