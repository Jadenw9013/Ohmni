B3 HAZARD: open secondary vs burdened secondary. Ip = 15 A pk, 50 kHz, N=200 -> Is = 75 mA pk (the 75 mA 'Isec max' of the AS-103 datasheet copy).
* v2 (REPIN-002): ct3_vopen_first removed from print; its meas line already prints it once.
* v2: added ct3_vopen_first = peak of v(s1) in the first microsecond (first saturation spike; converged and solver-independent, see report) and printed it; the 60-120 us peaks (ct3_vopen, ct3_vburd) are kept but are solver-step dependent (ringing) and are not contracted. Circuit unchanged.
* Magnetizing branch saturates at ISATM=0.05 A primary-referred (= 0.25 mA secondary; ASSUMPTION, no datasheet Isat) so the open core is deep in saturation.
* Expected: V_open_pk = Lsec*w*Is_pk = 0.01*314159*0.075 = 235.6 V (zero-crossing slope; saturation narrows the spikes but does not lower the peak)
* NUMERICS: the spike is ~30 ns wide; with step 20n the peak reads 1051 V (artifact), 5n gives 227-237, 1n gives 182. Needs tmax <= 0.5 ns here (see report).
*           V_burdened_pk = Is*Rb = 7.5 V
* OHMNI BEH-MAG-XFMR models (behavioural_approximation). Pins: p1 p2 s1 s2 (p1 and s1 are dot terminals).
* LP = primary open-circuit inductance, N = Ns/Np, LLK = leakage seen at primary with secondary shorted.
* RP, RS winding DC resistances. CIW = interwinding capacitance (one lumped C p1-s1 / p2-s2 split).
* Linear coupled-inductor version (K element).
.subckt XFMR_K p1 p2 s1 s2 LP=1m N=1 LLK=1u RP=1m RS=1m CIW=1p
.param kk={sqrt(1-LLK/LP)}
Rp1 p1 pa {RP}
L1 pa p2 {LP}
L2 sa s2 {LP*N*N}
Rs1 s1 sa {RS}
K12 L1 L2 {kk}
Ciw1 p1 s1 {CIW/2}
Ciw2 p2 s2 {CIW/2}
.ends

* Saturating version: leakage Llk in series on primary side, nonlinear magnetizing inductance across an ideal transformer.
* ISATM = magnetizing current at which Lm has dropped by DROP (referred to primary). LR = Lsat/Lm floor.
.subckt XFMR_SAT p1 p2 s1 s2 LP=1m N=1 LLK=1u RP=1m RS=1m CIW=1p ISATM=1 DROP=0.3 LR=0.05
.param lmag={LP-LLK}
.param ia={ISATM/atanh(sqrt(DROP/(1-LR)))}
Rp1 p1 pa {RP}
Llk pa pb {LLK}
Lm pb p2 L='lmag*(LR+(1-LR)*(1/cosh(max(min(i(Lm)/ia,20),-20)))**2)'
* ideal transformer v(sx,s2)=N*v(pb,p2); current N*i(Vs) forced pb->p2
Es sx s2 pb p2 {N}
Vs sx sb 0
Fp pb p2 Vs {N}
Rs1 s1 sb {RS}
Ciw1 p1 s1 {CIW/2}
Ciw2 p2 s2 {CIW/2}
.ends

Ip 0 p1 SIN(0 15 50k)
X1 p1 0 s1 0 XFMR_SAT LP=250n N=200 LLK=0.25n RP=1u RS=3 CIW=1p ISATM=0.05 DROP=0.3 LR=0.05
Rload s1 0 1G
.options reltol=1e-5
.tran 0.5n 120u 0 0.5n uic
.control
alter Rload = 1G
run
meas tran ct3_vopen_first max v(s1) from=0 to=1u
meas tran ct3_vopen max v(s1) from=60u to=120u
alter Rload = 100
run
meas tran ct3_vburd max v(s1) from=60u to=120u
quit
.endc
.end
