* BEH-REG-LINEAR B2: line and load regulation of the L7805-class model (ST L78 DS0422 Rev 38: line reg 50 mV typ 7.5-25 V; load reg 100 mV typ 5 mA-1.5 A; Vout 5 V)
* v2: absolute include path made relative; dline/dload renamed line_reg_v/load_reg_v (V); sweep tables kept
* Parameters: KLINE = 0.050/17.5 = 2.857 mV/V ; ROUTDC = 0.100/1.495 = 66.9 mohm ; GM=500 (so 1/GM = 2 mohm < ROUTDC)
* Analytic: Vout(Vin=7.5, 5 mA) = 5 + KLINE*(7.5-VINREF=10)... VINREF=10: Vout(10 V, 5 mA) = 5.000 - 0.0669*0.005 = 4.99967
*   line: Vout(25 V,5 mA) - Vout(7.5 V,5 mA) = 0.050 V (tolerance 5 %)
*   load: Vout(10 V,5 mA) - Vout(10 V,1.5 A) = 0.100 V (tolerance 5 %)
* OHMNI R6 linear-regulator behavioural subcircuit (fidelity: behavioural_approximation). NOT a vendor model.
* Pins: vin vout gnd.  The pass element is a controlled current source from vin to vout:
*   Idemand = GM*(Vreg - Vout)  -> two-pole lag (FP1, FP2) -> clamps: >=IFLOOR, <=ILIM (soft), <=(Vin-Vout)/Rdo (dropout), x thermal gate
*   Vreg = VNOM + KLINE*(Vin-VINREF) - (ROUTDC-1/GM)*Ipass     (line and load regulation; total DC output resistance = ROUTDC because the loop adds 1/GM; the coefficient is NEGATIVE when 1/GM > ROUTDC, i.e. a mild static positive feedback of gain GM*(1/GM-ROUTDC) < 1 that raises DC loop gain without adding a pole. Keep GM*ROUTDC >= 0.2 to stay well away from 1)
* NOTE: add .nodeset v(vout)=VNOM in every deck that has a load; without it ngspice 42 .op can land on a spurious solution (seen: Vout=0.18 V)
*   Rdo = VDO/IDO ; ground current = IQ + IQ1*Ipass ; thermal: Tj = Ta + Rth*P with Cth (RC node 'tj', 1 V = 1 C)
*   Dbody vout->vin models the reverse-current path (ASSUMPTION; real parts differ, see parts/R6.md)
.subckt LDO_R6 vin vout gnd params: VNOM=3.3 VINREF=5 KLINE=0.0005 ROUTDC=0.006 VDO=1.1 IDO=0.8 IQ=5m IQ1=0 ILIM=1.2 GM=50 FP1=2meg FP2=5meg TSD=165 THYS=20 RTH=60 CTH=0.05 TA=25 IFLOOR=0
Bvreg vreg gnd V=V(vnom_int)+{KLINE}*(V(vin,gnd)-{VINREF})-({ROUTDC}-1/{GM})*V(ipas,gnd)
Vn vnom_int gnd {VNOM}
Bdem dem gnd V={GM}*(V(vreg,gnd)-V(vout,gnd))
R1 dem d1 1
C1 d1 gnd {1/(6.2831853*FP1)}
Eb d1b gnd d1 gnd 1
R2 d1b d2 1
C2 d2 gnd {1/(6.2831853*FP2)}
* thermal gate with hysteresis-free soft knee (no latch): g=1 below TSD-THYS... gate midpoint TSD, width 1 C
Bg g gnd V=0.5*(1-tanh((V(tj,gnd)-{TSD})/1))
* clamps (all in amps; soft minimum/maximum with eps 1m)
* x1 = softmin(demand, ILIM); y = dropout current; ipas = softmax(IFLOOR, softmin(x1,y)) * thermal gate  (soft width ~2 mA)
Bx1 x1 gnd V=0.5*(V(d2,gnd)+{ILIM}-sqrt((V(d2,gnd)-{ILIM})**2+4e-6))
By1 y1 gnd V=(V(vin,gnd)-V(vout,gnd))/({VDO}/{IDO})
Bx2 x2 gnd V=0.5*(V(x1,gnd)+V(y1,gnd)-sqrt((V(x1,gnd)-V(y1,gnd))**2+4e-6))
Bipas ipas gnd V=(0.5*(V(x2,gnd)+{IFLOOR}+sqrt((V(x2,gnd)-{IFLOOR})**2+4e-6)))*V(g,gnd)
Rdum ipas gnd 1G
Gp vin vout cur='V(ipas,gnd)'
* ground (quiescent) current
Gq vin gnd cur='{IQ}+{IQ1}*V(ipas,gnd)'
* power -> thermal node
Gpw gnd tj cur='min(max(V(vin,vout),0),V(vin,gnd))*V(ipas,gnd)+V(vin,gnd)*({IQ}+{IQ1}*V(ipas,gnd))'
Rth tj ta {RTH}
Cth tj ta {CTH}
Vta ta gnd {TA}
Dbody vout vin DREV
.model DREV D(IS=1e-12 N=1.5 RS=0.3)
.ends

Vin vin 0 10
X1 vin vout 0 LDO_R6 VNOM=5 VINREF=10 KLINE=0.002857 ROUTDC=0.0669 VDO=2 IDO=1 IQ=5m ILIM=2.2 GM=500 FP1=300k FP2=1meg RTH=50 TSD=500
Iload vout 0 0.005
.nodeset v(vout)=5
.control
set noaskquit
dc Vin 7.5 25 17.5
print v(vout)
let dline = v(vout)[1]-v(vout)[0]
let line_reg_v = dline
print line_reg_v
dc Iload 0.005 1.5 1.495
print v(vout)
let dload = v(vout)[0]-v(vout)[1]
let load_reg_v = dload
print load_reg_v
quit
.endc
.end
