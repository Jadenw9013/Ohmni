* BEH-IC-COMPARATOR B2: response time, falling output, RL=5.1k to 5 V, CL=15 pF (TI test circuit conditions), Vos=0.
* v2: scalars printed as 'name = value'; behavior unchanged
* (a) 100 mV step with 5 mV overdrive: expect ~1.3 us (TI typ) -- calibration target
* (b) large (TTL-level) overdrive: expect ~0.3 us (TI typ) -- calibration target
* Model analytic: t = td + tau*ln(1+Vs/(A*vod)) = 0.3u + 1.44u*ln(1+1/(200*0.005)) = 1.298 us ; large overdrive 1.4 V: 0.3u+1.44u*ln(1+1/280)=0.305 us ; plus output edge ~ Ron*... small
* BEH-IC-COMPARATOR open-collector comparator macromodel (behavioural_approximation), LM393 numbers (TI SLCS005AH extract).
* pins: inp inm vcc gnd out   (one of two channels; package binding picks the channel pins)
* IN+ > IN- (+ offset): output transistor off (high-Z, leakage ioh); IN+ < IN-: output sinks, Ron-limited with Isat.
* Response: dominant-pole node n1 (clamped to +-Vs) chases A*vd -> trips when it crosses 0: t = td + tau*ln(1+Vs/(A*vod)); calibrated to 1.3 us @5 mV overdrive and 0.3 us @ TTL step.
.subckt comp_oc inp inm vcc gnd out params: vos=2m ib=25n ios=3n ron=33 isat=16m a=200 vs=1 tau=1.44u td=0.3u icc=450u ioh=1n
Vos ip1 inp dc {vos}
Ibp vcc ip1 dc {ib+ios/2}
Ibm vcc inm dc {ib-ios/2}
Bt tgt gnd V=max(min({a}*(v(ip1)-v(inm)),100),-100)
* n1 integrates toward tgt with time constant tau but is held inside +-Vs (gate switches the charging current off smoothly at the limits)
Bn gnd n1 I=max(v(tgt)-v(n1),0)*0.5*(1-tanh((v(n1)-{vs})/0.01))+min(v(tgt)-v(n1),0)*0.5*(1+tanh((v(n1)+{vs})/0.01))
C1 n1 gnd {tau} ic=0
Rl1 n1 gnd 1e12
Rsd n1 d2 50
T1 d2 gnd d3 gnd Z0=50 TD={td}
Rtd d3 gnd 50
Bsh sh gnd V=2*v(d3)
* output sinks when sh < 0
Bout out gnd I=0.5*(1-tanh(v(sh)/0.02))*{isat}*tanh((v(out)-v(gnd))/({ron}*{isat}))+{ioh}
Icc vcc gnd dc {icc}
.ends

Vcc vcc 0 5
Vref ref 0 2.5
* (a): IN+ starts 100 mV above ref, steps to 5 mV below ref -> output goes low
Va ina 0 pwl(0 2.6 1u 2.6 1.001u 2.495 10u 2.495)
Xa ina ref vcc 0 outa comp_oc vos=0 ib=0 ios=0
Rla vcc outa 5.1k
Cla outa 0 15p
* (b): step 1.4 V overdrive
Vb inb 0 pwl(0 3.9 1u 3.9 1.001u 1.1 10u 1.1)
Xb inb ref vcc 0 outb comp_oc vos=0 ib=0 ios=0
Rlb vcc outb 5.1k
Clb outb 0 15p
.tran 5n 10u
.control
set noaskquit
run
meas tran ta trig v(ina) val=2.5 fall=1 targ v(outa) val=2.5 fall=1
meas tran tb trig v(inb) val=2.5 fall=1 targ v(outb) val=2.5 fall=1
let tau = ta*1e6
let tbb = tb*1e6
echo t_5mv_us = $&tau
echo t_ttl_us = $&tbb
quit
.endc
.end
