* B6: Vf temperature coefficient of all four LED cards at 20 mA, 0 C to 85 C (tempco targets are ASSUMPTIONs, about -2 to -3 mV/K)
* OHMNI BEH-LED-INDICATOR D-model cards (behavioural_approximation, NOT vendor models)
* Extracted by /home/claude/behavior/tmp_R5_fit.py from Vishay datasheet table and chart points, see R5.md S2..S6
* TNOM=27 C. CJO values from datasheet Cj where given (red 30 pF @0V TLDR4400; green 50 pF TLHG5800); others ASSUMPTION.
.model LED_RED   D (IS=1.846e-16 N=2.0  RS=16.4 CJO=30p VJ=1.0 M=0.33 TT=0 BV=15 IBV=10u EG=2.2 XTI=3)
.model LED_GREEN D (IS=3.793e-18 N=2.38 RS=8.76 CJO=50p VJ=1.0 M=0.33 TT=0 BV=15 IBV=10u EG=2.8 XTI=3)
.model LED_BLUE  D (IS=7.641e-24 N=3.0  RS=6.28 CJO=60p VJ=1.0 M=0.33 TT=0 BV=5.5 IBV=10u EG=4.6 XTI=3)
.model LED_WHITE D (IS=1.247e-19 N=3.0  RS=6.3  CJO=60p VJ=1.0 M=0.33 TT=0 BV=5.5 IBV=10u EG=3.9 XTI=3)
* RGB package dies anchored on Broadcom ASMB-MTB0-0A3A2 typical VF at 20 mA (red 2.1 V, green 3.1 V, blue 3.1 V); N, RS assumed (S-ASSUMPTION)
.model LED_RGB_R D (IS=4.848e-18 N=2.0 RS=12  CJO=30p VJ=1.0 M=0.33 BV=5.5 IBV=10u EG=2.2 XTI=3)
.model LED_RGB_GB D (IS=4.526e-19 N=3.0 RS=6.3 CJO=60p VJ=1.0 M=0.33 BV=5.5 IBV=10u EG=4.0 XTI=3)

I1 0 a1 DC 20m
I2 0 a2 DC 20m
I3 0 a3 DC 20m
I4 0 a4 DC 20m
DR a1 0 LED_RED
DG a2 0 LED_GREEN
DB a3 0 LED_BLUE
DW a4 0 LED_WHITE
.control
dc temp 0 85 85
let d1=(v(a1)[1]-v(a1)[0])/85
let d2=(v(a2)[1]-v(a2)[0])/85
let d3=(v(a3)[1]-v(a3)[0])/85
let d4=(v(a4)[1]-v(a4)[0])/85
print d1 d2 d3 d4
.endc
.end
