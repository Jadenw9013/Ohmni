* BEH-TRN-MOSFET B5: body diode forward drop at IS = 25 A, Vgs = 0, IRFZ44N_R6.  Datasheet VSD = 1.3 V max (Infineon IRFZ44NPbF, Is=25 A, Vgs=0, 25 C)
* v2: absolute include path made relative; printed named scalar vsd_v
* Fitted by construction (IS, N=1.2 assumed, RS = 8 mohm assumed): expected 1.3 V, tolerance 3 %.  Result confirms parameter transcription only.
* OHMNI R6 N-channel MOSFET behavioural subcircuits, parameters fitted from datasheet numbers (see parts/R6.md BEH-TRN-MOSFET).
* fidelity: behavioural_approximation. NOT vendor models. Rds(on) fitted to datasheet MAX values (worst case). Pins: d g s.
* Dynamic part: Cgs const, Cgd nonlinear (charge-based capacitor q=Q(Vgd), Cgd=Cmin+(Cmax-Cmin)/(1+exp(-Vgd/0.9))), Cds + body diode junction capacitance (abrupt, M=0.5, VJ=0.8).
.model NM_IRFZ44N NMOS(LEVEL=1 VTO=3.0 KP=10.17 IS=0 RD=0.0015 RS=0.0015)
.subckt IRFZ44N_R6 d g s params: BVDSS=55
Rg g gi 3.0
M1 d gi s s NM_IRFZ44N
Cgs gi s 1382p
* Cgd: Cmin=88p (Crss), Cmax=3666p, transition width ~Vgs plateau 5.22 V centred at Vdg=0
Cgd gi d q='88p*(v(gi)-v(d)) + (3666.3p-88p)*0.9*ln(1+exp((v(gi)-v(d))/0.9))'
Dbody s d DB_IRFZ44N
.model DB_IRFZ44N D(IS=1.015e-14 N=1.2 RS=0.008 TT=14n CJO=1545p VJ=0.8 M=0.5 BV={BVDSS})
.ends
.model NM_IRF540N NMOS(LEVEL=1 VTO=3.0 KP=3.6688 IS=0 RD=0.0015 RS=0.0015)
.subckt IRF540N_R6 d g s params: BVDSS=100
Rg g gi 3.0
M1 d gi s s NM_IRF540N
Cgs gi s 1920p
Cgd gi d 40p
Dbody s d DB_IRF540N
.model DB_IRF540N D(IS=1.258e-13 N=1.2 RS=0.012 TT=0 CJO=1193p VJ=0.8 M=0.5 BV={BVDSS})
.ends
.model NM_IRLB8721 NMOS(LEVEL=3 VTO=1.85 KP=37.23 THETA=0.14341 ETA=0 KAPPA=0 DELTA=0 VMAX=0 IS=0 RD=0.00075 RS=0.00075)
.subckt IRLB8721_R6 d g s params: BVDSS=30
Rg g gi 2.0
M1 d gi s s NM_IRLB8721
Cgs gi s 967p
Cgd gi d 110p
Dbody s d DB_IRLB8721
.model DB_IRLB8721 D(IS=1.055e-12 N=1.2 RS=0.004 TT=0 CJO=1420p VJ=0.8 M=0.5 BV={BVDSS})
.ends
.model NM_IRFP260N NMOS(LEVEL=1 VTO=3.0 KP=4.1967 IS=0 RD=0.0015 RS=0.0015)
.subckt IRFP260N_R6 d g s params: BVDSS=200
Rg g gi 2.0
M1 d gi s s NM_IRFP260N
Cgs gi s 4057p
Dbody s d DB_IRFP260N
.model DB_IRFP260N D(IS=2.463e-14 N=1.2 RS=0.008 TT=0  BV={BVDSS})
.ends
.model NM_SI7898DP NMOS(LEVEL=3 VTO=3.0 KP=25.343 THETA=1.8438 ETA=0 KAPPA=0 DELTA=0 VMAX=0 IS=0 RD=0.0025 RS=0.0025)
.subckt SI7898DP_R6 d g s params: BVDSS=150
Rg g gi 1.5
M1 d gi s s NM_SI7898DP
Cgs gi s 1700p
Dbody s d DB_SI7898DP
.model DB_SI7898DP D(IS=2.271e-15 N=1.2 RS=0.05 TT=0  BV={BVDSS})
.ends
.model NM_2N7000 NMOS(LEVEL=3 VTO=1.9 KP=0.20959 THETA=0.75509 ETA=0 KAPPA=0 DELTA=0 VMAX=0 IS=0 RD=0.025 RS=0.025)
.subckt 2N7000_R6 d g s params: BVDSS=60
Rg g gi 10
M1 d gi s s NM_2N7000
Cgs gi s 55p
Cgd gi d 5p
Dbody s d DB_2N7000
.model DB_2N7000 D(IS=1e-14 N=1.2 RS=1.0 TT=0 CJO=114p VJ=0.8 M=0.5 BV={BVDSS})
.ends
.model NM_2N7002 NMOS(LEVEL=3 VTO=1.75 KP=0.36327 THETA=1.4067 ETA=0 KAPPA=0 DELTA=0 VMAX=0 IS=0 RD=0.025 RS=0.025)
.subckt 2N7002_R6 d g s params: BVDSS=60
Rg g gi 10
M1 d gi s s NM_2N7002
Cgs gi s 50p
Dbody s d DB_2N7002
.model DB_2N7002 D(IS=1e-14 N=1.2 RS=1.0 TT=0  BV={BVDSS})
.ends

Isrc 0 s 25
X1 0 g s IRFZ44N_R6 BVDSS=55
Vg g s 0
.control
set noaskquit
op
let vsd_v = v(s)
print vsd_v
quit
.endc
.end
