* BEH-IC-OPTO-DIP6 B1: transfer and saturation. Vcc=5 V, RL=470 ohm collector load, LED current set by 5 V and series resistor.
* v2: scalars printed as 'name = value'; behavior unchanged
* (a) IF~2 mA (1.9k from 5 V, VF~1.1 V: IF = (5-1.1)/1.9k = 2.05 mA), CTR=1.0 -> Ic = CTR*IF = 2.05 mA -> Vc = 5 - 470*2.05m = 4.04 V (printed VF/Vc)
* (b) IF~10 mA (380 ohm) -> Ic would be 10 mA but 470 ohm limits to ~ (5-Vcesat)/470 = 10.2 mA minus -> saturates: Vce ~ 0.15*atanh(...)  (expect ~0.07..0.2 V, datasheet VCEsat typ 0.3..0.4 V at larger IC)
* BEH-IC-OPTO-DIP6 phototransistor optocoupler (4N35 class), behavioural_approximation. ngspice 42 stock.
* pins: an cat c e  (anode, cathode, collector, emitter); base (pin 6) not modelled (left open in the typical application; see class text)
* LED: diode, VF ~1.2 V @10 mA (Vishay 83717 extract 1.2..1.5 V). Output: Ic = CTR*IF*tanh(Vce/vsat), CTR constant (the real CTR varies with IF, temperature and ageing: not modelled).
.model dled d(is=1.5e-13 n=1.8 rs=4 cjo=30p)
.subckt opto_pt an cat c e params: ctr=1.0 vsat=0.15 ioff=5n
Dled ai cat dled
Vsn an ai 0
Bc c e I=0.0+{ctr}*max(i(Vsn),0)*tanh(max(v(c)-v(e),0)/{vsat})+{ioff}
.ends

Vcc vcc 0 5
Rsa vcc ana 1.9k
Xa ana 0 ca 0 opto_pt
Rla vcc ca 470
Rsb vcc anb 380
Xb anb 0 cb 0 opto_pt
Rlb vcc cb 470
.control
set noaskquit
op
let vfa = v(ana)
let vca = v(ca)
let vfb = v(anb)
let vcb = v(cb)
echo vf_a_v = $&vfa
echo vc_2ma_v = $&vca
echo vf_b_v = $&vfb
echo vc_10ma_v = $&vcb
quit
.endc
.end
