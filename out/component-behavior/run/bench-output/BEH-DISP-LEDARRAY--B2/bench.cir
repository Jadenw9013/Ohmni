* B2: 4-digit common-cathode multiplex (one lit segment per digit), digit-select switches Ron=10 ohm, 4 slots of 249 us in 1 ms
* OHMNI BEH-LED-INDICATOR D-model cards (behavioural_approximation, NOT vendor models)
* Extracted by /home/claude/behavior/tmp_R5_fit.py from Vishay datasheet table and chart points, see R5.md S2..S6
* TNOM=27 C. CJO values from datasheet Cj where given (red 30 pF @0V TLDR4400; green 50 pF TLHG5800); others ASSUMPTION.
.model LED_RED   D (IS=1.846e-16 N=2.0  RS=16.4 CJO=30p VJ=1.0 M=0.33 TT=0 BV=15 IBV=10u EG=2.2 XTI=3)
.model LED_GREEN D (IS=3.793e-18 N=2.38 RS=8.76 CJO=50p VJ=1.0 M=0.33 TT=0 BV=15 IBV=10u EG=2.8 XTI=3)
.model LED_BLUE  D (IS=7.641e-24 N=3.0  RS=6.28 CJO=60p VJ=1.0 M=0.33 TT=0 BV=5.5 IBV=10u EG=4.6 XTI=3)
.model LED_WHITE D (IS=1.247e-19 N=3.0  RS=6.3  CJO=60p VJ=1.0 M=0.33 TT=0 BV=5.5 IBV=10u EG=3.9 XTI=3)
* RGB package dies anchored on Broadcom ASMB-MTB0-0A3A2 typical VF at 20 mA (red 2.1 V, green 3.1 V, blue 3.1 V); N, RS assumed (S-ASSUMPTION)
.model LED_RGB_R D (IS=4.848e-18 N=2.0 RS=12  CJO=30p VJ=1.0 M=0.33 BV=5.5 IBV=10u EG=2.2 XTI=3)
.model LED_RGB_GB D (IS=4.526e-19 N=3.0 RS=6.3 CJO=60p VJ=1.0 M=0.33 BV=5.5 IBV=10u EG=4.0 XTI=3)

.model SW1 SW(Ron=10 Roff=1G Vt=2.5 Vh=0.1)
VCC vcc 0 5
RSEG vcc seg 150
VSEG seg s2 0
VDIG0 g0 0 PULSE(0 5 0u 1n 1n 249u 1m)
VD0 s2 sd0 0
DSEG0 sd0 k0 LED_RED
S0 k0 0 g0 0 SW1
VDIG1 g1 0 PULSE(0 5 250u 1n 1n 249u 1m)
VD1 s2 sd1 0
DSEG1 sd1 k1 LED_RED
S1 k1 0 g1 0 SW1
VDIG2 g2 0 PULSE(0 5 500u 1n 1n 249u 1m)
VD2 s2 sd2 0
DSEG2 sd2 k2 LED_RED
S2 k2 0 g2 0 SW1
VDIG3 g3 0 PULSE(0 5 750u 1n 1n 249u 1m)
VD3 s2 sd3 0
DSEG3 sd3 k3 LED_RED
S3 k3 0 g3 0 SW1
.tran 2u 20m 0 2u
.meas tran iseg AVG i(VSEG) FROM=2m TO=20m
.meas tran idig AVG i(VD0) FROM=2m TO=20m
.meas tran ipk MAX i(VD0) FROM=2m TO=20m
.end
