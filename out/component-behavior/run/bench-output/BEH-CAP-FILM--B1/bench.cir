B1 Film capacitor dissipation factor from ESR: tan(delta) = Re(Z)/|Im(Z)| at FREF
* C=1u, TAND=20e-4 (WIMA MKP-X2 1 kHz class value) at 1 kHz; expect 0.0020 (ESL has negligible effect at 1 kHz)
* OHMNI BEH-CAP-FILM subcircuit (metallised film, incl. X2), behavioural_approximation
* ports: p n flag. flag bitmask: 1 = |V| > VRPK (peak rating; for AC-rated parts VRPK = sqrt(2)*Vrms)
* ESR is a constant chosen from tan(delta) at a reference frequency: ESR = TAND/(2*pi*FREF*C0) (real tan(delta) rises with f, see doc)
.subckt ohm_film p n flag params: C0=1u TAND=20e-4 FREF=1k ESL=15n RLK=15g VRPK=388.9
.param ESRV={TAND/(2*3.14159265358979*FREF*C0)}
Lesl p a {ESL}
Resr a b {ESRV}
Cb b n {C0}
Rlk b n {RLK}
Bflag flag 0 V = 'abs(v(b,n)) > {VRPK} ? 1 : 0'
.ends

Iac 0 p dc 0 ac 1
Rb p 0 1e12
Xc p 0 f ohm_film C0=1u TAND=20e-4 FREF=1k ESL=15n RLK=1e15
Rf f 0 1meg
.ac lin 1 1k 1k
.control
run
let tand = real(v(p))/abs(imag(v(p)))
print tand
quit
.endc
.end
