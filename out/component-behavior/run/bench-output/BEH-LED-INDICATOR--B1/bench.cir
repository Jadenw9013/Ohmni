* B1: model reproduces the datasheet VF-IF points used for the fit (L1, op/dc)
* v2: after the sweep loop, re-solve op at 20 mA and print scalar vred_20ma (loop only echoed strings); loop unchanged
* OHMNI BEH-LED-INDICATOR D-model cards (behavioural_approximation, NOT vendor models)
* Extracted by /home/claude/behavior/tmp_R5_fit.py from Vishay datasheet table and chart points, see R5.md S2..S6
* TNOM=27 C. CJO values from datasheet Cj where given (red 30 pF @0V TLDR4400; green 50 pF TLHG5800); others ASSUMPTION.
.model LED_RED   D (IS=1.846e-16 N=2.0  RS=16.4 CJO=30p VJ=1.0 M=0.33 TT=0 BV=15 IBV=10u EG=2.2 XTI=3)
.model LED_GREEN D (IS=3.793e-18 N=2.38 RS=8.76 CJO=50p VJ=1.0 M=0.33 TT=0 BV=15 IBV=10u EG=2.8 XTI=3)
.model LED_BLUE  D (IS=7.641e-24 N=3.0  RS=6.28 CJO=60p VJ=1.0 M=0.33 TT=0 BV=5.5 IBV=10u EG=4.6 XTI=3)
.model LED_WHITE D (IS=1.247e-19 N=3.0  RS=6.3  CJO=60p VJ=1.0 M=0.33 TT=0 BV=5.5 IBV=10u EG=3.9 XTI=3)
* RGB package dies anchored on Broadcom ASMB-MTB0-0A3A2 typical VF at 20 mA (red 2.1 V, green 3.1 V, blue 3.1 V); N, RS assumed (S-ASSUMPTION)
.model LED_RGB_R D (IS=4.848e-18 N=2.0 RS=12  CJO=30p VJ=1.0 M=0.33 BV=5.5 IBV=10u EG=2.2 XTI=3)
.model LED_RGB_GB D (IS=4.526e-19 N=3.0 RS=6.3 CJO=60p VJ=1.0 M=0.33 BV=5.5 IBV=10u EG=4.0 XTI=3)

I1 0 a1 DC 20m
I2 0 a2 DC 20m
I3 0 a3 DC 20m
I4 0 a4 DC 20m
DR a1 0 LED_RED
DG a2 0 LED_GREEN
DB a3 0 LED_BLUE
DW a4 0 LED_WHITE
.control
foreach cur 0.001 0.010 0.020 0.050 0.100
  alter I1 dc = $cur
  alter I2 dc = $cur
  alter I3 dc = $cur
  alter I4 dc = $cur
  op
  echo I=$cur  Vred=$&v(a1) Vgreen=$&v(a2) Vblue=$&v(a3) Vwhite=$&v(a4)
end
alter I1 dc = 0.020
op
let vred_20ma = v(a1)
print vred_20ma
quit
.endc
.end
