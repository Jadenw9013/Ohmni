B2 Oscillator output-disable: OE pulled low (0 V) -> output held low, supply current drops to standby (1 uA)
* v2 (REPIN-001): vout_max_v removed from print; its meas line already prints it once.
* v2: scalars printed: vout_max_v, icc_sb_a (positive standby current); circuit unchanged
* OHMNI packaged clock oscillator, L2 behavioural. Pins: vdd gnd oe out.
* f0 nominal Hz, ppm total static offset (init tol + temp + aging, user-set), tstart start-up delay (s),
* icc operating supply current (A), icc_sb standby current (A), rout CMOS output resistance, tr rise/fall time, vmin min supply for operation, vth_oe enable threshold fraction of VDD.
.subckt ohm_xo vdd gnd oe out f0=10meg ppm=0 tstart=5u icc=4.2m icc_sb=1u rout=30 tr=1n vmin=2.25 vth_oe=0.7
.param fa={f0*(1+ppm*1e-6)} pr={1/fa}
Vclk clk gnd PULSE(0 1 {tstart} {tr} {tr} {0.5*pr-tr} {pr})
* enabled when supply valid AND (oe floating-high or above threshold)
Bdrv drv gnd V = (V(vdd,gnd)>{vmin}) ? ((V(oe,gnd)>{vth_oe}*V(vdd,gnd)) ? V(vdd,gnd)*V(clk,gnd) : 0) : 0
Ro drv out {rout}
Bi vdd gnd I = (V(vdd,gnd)>{vmin}) ? ((V(oe,gnd)>{vth_oe}*V(vdd,gnd)) ? {icc} : {icc_sb}) : 0
.ends ohm_xo

Vdd vdd 0 3.3
Voe oe 0 0
Xo vdd 0 oe out ohm_xo f0=10meg ppm=0 tstart=5u icc=4.2m icc_sb=1u
Cl out 0 15p
.tran 1n 25u
.control
run
meas tran vout_max_v MAX v(out) FROM=10u TO=20u
meas tran idd AVG i(Vdd) FROM=10u TO=20u
let icc_sb_a = -idd
print icc_sb_a
quit
.endc
.end
