RC smoke
V1 in 0 PULSE(0 5 0 1n 1n 1 2)
R1 in out 1k
C1 out 0 1u
.tran 10u 5m
.control
run
meas tran v63 find v(out) at=1m
quit
.endc
.end
