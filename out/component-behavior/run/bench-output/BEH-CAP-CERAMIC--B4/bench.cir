B4 MLCC over-rated-voltage flag (VR=10 V)
* ramp 0..12 V in 12 s; flag must switch 0->1 when |v|>10 i.e. at t=10 s
* OHMNI BEH-CAP-CERAMIC subcircuit, behavioural_approximation
* ports: p n flag ; flag node voltage is a bitmask: 1=overvoltage, 2=reverse(not used for ceramic)
.subckt ohm_mlcc p n flag params: C0=1u V0=1e6 ESR=5m ESL=0.7n RLK=1e9 VR=10 AGE=0 TCDEV=0
Lesl p a {ESL}
Resr a b {ESR}
* charge-based DC-bias capacitor: q = Ceff0*V0*atan(v/V0) so dq/dv = Ceff0/(1+(v/V0)^2)
Cb b n q = '{C0*(1-AGE)*(1+TCDEV)}*{V0}*atan(v(b,n)/{V0})'
Rlk b n {RLK}
Bflag flag 0 V = 'abs(v(b,n)) > {VR} ? 1 : 0'
.ends

Vr in 0 PWL(0 0 12 12)
Rs in p 1
Xc p 0 f ohm_mlcc C0=1u V0=1e6 ESR=1m ESL=1p RLK=1e12 VR=10
Rf f 0 1meg
.tran 0.01 12
.control
run
meas tran tflag when v(f)=0.5 rise=1
meas tran fl_at_9 find v(f) at=9
meas tran fl_at_11 find v(f) at=11
quit
.endc
.end
