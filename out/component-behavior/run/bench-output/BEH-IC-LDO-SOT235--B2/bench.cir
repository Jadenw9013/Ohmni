* BEH-IC-LDO-SOT235 B2: load regulation and current limit. Vin = 5 V.
* v2: sweep points read with meas dc FIND AT; added delta_mv = (V(1mA)-V(200mA))*1000 and scalar prints; behavior unchanged
* Hard-knee ideal: Vout(1 mA)=3.29996, Vout(200 mA)=3.292 -> delta 8 mV (datasheet 1..15 mV over the full load range).
* Exact solution of the implemented soft-knee equations (python bisection): 3.30002 V @1 mA (with 1 Mohm feedback load), 3.29027 V @200 mA -> delta 9.7 mV (inside the 1..15 mV datasheet range).
* Current limit: Icl = 0.43 A (ASSUMED between TI min 220 mA and max 860 mA); see B2b
* BEH-IC-LDO-SOT235 behavioural LDO for the TLV700xx family (TLV70033 = 3.3 V). behavioural_approximation. ngspice 42 stock.
* pins: in gnd en out   (SOT-23-5 DDC order is IN=1 GND=2 EN=3 NC=4 OUT=5; the package binding maps these)
* Pass element = current source I = icl*tanh(Iraw/icl)*enable*(1-shutdown), Iraw = a*b/(a+b) with a=(Vreg-Vout)/rout (regulation branch) and b=(Vin-Vout)/rdo (dropout branch): soft knee, output impedance ~rout, dropout resistance ~rdo, current limit icl, cannot sink current. (Smooth form chosen because hard min() kinks made ngspice's op solve fail.)
* Thermal: Pd -> Rth_ja -> Ta; memoryless thermal limiter: output current scaled by (1 - 0.5*(1+tanh((Tj-tsd_hi)/2))). The real part has hysteresis (~160 C off, ~140 C on, TI SLVSA00E extract) - NOT modelled (a latch has no unique DC solution); the model regulates at ~tsd_hi (time-average of the real thermal cycling). cth is an ASSUMPTION.
.subckt tlv700 in gnd en out params: vnom=3.3 acc=0 rdo=0.86 rout=0.04 icl=0.43 iq=31u ign200=270u ven_hi=0.9 ven_lo=0.4 rth=235.9 ta=25 tsd_hi=160 cth=0.05
* enable (hysteretic latch not modelled; single threshold at the mean of ven_hi/ven_lo)
Ben enb gnd V=0.5*(1+tanh((v(en)-v(gnd)-0.5*({ven_hi}+{ven_lo}))/0.02))
* thermal network: temperature in volts (1 V = 1 degC)
Vta tamb gnd dc {ta}
Rth tj tamb {rth}
Cth tj tamb {cth} ic=0
Bpd gnd tj I=max((v(in)-v(out))*v(ip)+v(in)*v(enb)*(iq+(ign200-iq)*min(max(v(ip)/0.2,0),1)),0)
Bts ts gnd V=0.5*(1+tanh((v(tj)-{tsd_hi})/2))
* pass element
Bip ip gnd V=v(enb)*(1-v(ts))*{icl}*tanh( ( ((0.5*(({vnom}*(1+acc)-(v(out)-v(gnd)))+sqrt(({vnom}*(1+acc)-(v(out)-v(gnd)))*({vnom}*(1+acc)-(v(out)-v(gnd)))+1e-8)))/{rout}+1e-9)*((0.5*((v(in)-v(out))+sqrt((v(in)-v(out))*(v(in)-v(out))+1e-8)))/{rdo}+1e-9) / (((0.5*(({vnom}*(1+acc)-(v(out)-v(gnd)))+sqrt(({vnom}*(1+acc)-(v(out)-v(gnd)))*({vnom}*(1+acc)-(v(out)-v(gnd)))+1e-8)))/{rout}+1e-9)+((0.5*((v(in)-v(out))+sqrt((v(in)-v(out))*(v(in)-v(out))+1e-8)))/{rdo}+1e-9)) )/{icl} )
Rip ip gnd 1e9
Bpass in out I=v(ip)
* internal feedback divider load (ASSUMED 1 Mohm, ~3 uA): also gives the output node a conductance to ground
Rfb out gnd 1Meg
* ground / quiescent current
Biq in gnd I=v(enb)*(iq+(ign200-iq)*min(max(v(ip)/0.2,0),1))
.ends

Vin in 0 5
Ven en 0 5
X1 in 0 en out tlv700
Iload out 0 dc 1m
.nodeset v(x1.tj)=25 v(out)=3.0
.control
set noaskquit
dc Iload 0.001 0.2 0.001
meas dc v1 find v(out) at=0.001
meas dc v2 find v(out) at=0.2
let delta_mv = (v1-v2)*1000
echo vout_1ma_v = $&v1
echo vout_200ma_v = $&v2
echo delta_mv = $&delta_mv
quit
.endc
.end
