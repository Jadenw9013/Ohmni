B3 SRF and Q of a 15 nH RF wirewound chip (Murata LQW18AN15NJ10D: SRF 4.5 GHz min? listed 'max SRF 4.5GHz', Q 42 min, DCR 85 mohm max)
* v2: added max_at (ind3_fpk = frequency of |Z| peak), meas renamed ind3_*, RESULT echo replaced by scalar ind3_q = Im/Re at 100 MHz (circuit unchanged)
* Expected: f_peak = 1/(2 pi sqrt(L*Cp)) = 4.5 GHz ; Q(100 MHz) = Im(Z)/Re(Z) = 42 (Q test frequency ASSUMED 100 MHz)
* OHMNI BEH-MAG-INDUCTOR realistic model (behavioural_approximation)
* Pins: a b. Params: L0 [H], Isat [A] at inductance drop DROP, LR = Lsat/L0 floor,
* RDC [ohm], CP [F] (from SRF), RP [ohm] (parallel loss).
.subckt IND_SAT a b L0=1u Isat=5 DROP=0.3 LR=0.05 RDC=10m CP=1p RP=1e9
.param ia={Isat/atanh(sqrt(DROP/(1-LR)))}
Rdc a x {RDC}
Lnl x b L='L0*(LR+(1-LR)*(1/cosh(max(min(i(Lnl)/ia,20),-20)))**2)'
Cp a b {CP}
Rp a b {RP}
.ends

* Same model plus self-heating. Node th is the temperature rise in degC (1 V = 1 degC).
* RTH [degC/W], CTH [J/degC], TC copper tempco [1/degC].
.subckt IND_SAT_TH a b th L0=1u Isat=5 DROP=0.3 LR=0.05 RDC=10m CP=1p RP=1e9 RTH=40 CTH=0.05 TC=3.93m
.param ia={Isat/atanh(sqrt(DROP/(1-LR)))}
Rdc a x R='RDC*(1+TC*v(th))'
Lnl x b L='L0*(LR+(1-LR)*(1/cosh(max(min(i(Lnl)/ia,20),-20)))**2)'
Cp a b {CP}
Rp a b {RP}
Bpw 0 th I='v(a,x)*v(a,x)/(RDC*(1+TC*v(th)))'
Rth th 0 {RTH}
Cth th 0 {CTH}
.ends

I1 0 p DC 0 AC 1
X1 p 0 IND_SAT L0=15n Isat=100 DROP=0.3 LR=0.05 RDC=85m CP=83.39f RP=637.2
R1 p 0 1G
.ac dec 400 10meg 20g
.control
run
meas ac ind3_zpk max vm(p)
meas ac ind3_fpk max_at vm(p)
meas ac ind3_xim find vi(p) at=100meg
meas ac ind3_xre find vr(p) at=100meg
let ind3_q = ind3_xim/ind3_xre
print ind3_q ind3_fpk
quit
.endc
.end
