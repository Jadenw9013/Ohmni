* BEH-REG-LINEAR B3: load step 0.1 A -> 0.8 A (1 us edge) on the AMS1117-3.3-class model, Vin = 5 V, Cout = 22 uF with ESR 0.3 ohm vs 0.01 ohm
* v2: absolute include path made relative; added pre-step averages and undershoot scalars (under1_mv, under2_mv, vfin1_v, vfin2_v); circuit unchanged
* Analytic: settled Vout after the step = VNOM + KLINE*(Vin-VINREF) - ROUTDC*Iout = 3.3 + 0 - 0.006*0.8 = 3.2952 V (tolerance 0.1 %).
* Upper bound of the transient undershoot: the output cap supplies the whole step until the loop responds, so the instantaneous drop is at most dI*ESR = 0.7*0.3 = 0.21 V (case 1) / 7 mV (case 2).
* A loop with fast response (GM = 40 S -> fu = GM/(2*pi*C) = 289 kHz) catches the step in ~1 us, so the undershoot is far below that bound: expected 5 mV < undershoot < 0.21 V.
* NOTE GM, FP1, FP2 are ASSUMPTIONS (the datasheets opened give no loop bandwidth); only the settled value is analytically checked, the undershoot only against the bound.
* OHMNI R6 linear-regulator behavioural subcircuit (fidelity: behavioural_approximation). NOT a vendor model.
* Pins: vin vout gnd.  The pass element is a controlled current source from vin to vout:
*   Idemand = GM*(Vreg - Vout)  -> two-pole lag (FP1, FP2) -> clamps: >=IFLOOR, <=ILIM (soft), <=(Vin-Vout)/Rdo (dropout), x thermal gate
*   Vreg = VNOM + KLINE*(Vin-VINREF) - (ROUTDC-1/GM)*Ipass     (line and load regulation; total DC output resistance = ROUTDC because the loop adds 1/GM; the coefficient is NEGATIVE when 1/GM > ROUTDC, i.e. a mild static positive feedback of gain GM*(1/GM-ROUTDC) < 1 that raises DC loop gain without adding a pole. Keep GM*ROUTDC >= 0.2 to stay well away from 1)
* NOTE: add .nodeset v(vout)=VNOM in every deck that has a load; without it ngspice 42 .op can land on a spurious solution (seen: Vout=0.18 V)
*   Rdo = VDO/IDO ; ground current = IQ + IQ1*Ipass ; thermal: Tj = Ta + Rth*P with Cth (RC node 'tj', 1 V = 1 C)
*   Dbody vout->vin models the reverse-current path (ASSUMPTION; real parts differ, see parts/R6.md)
.subckt LDO_R6 vin vout gnd params: VNOM=3.3 VINREF=5 KLINE=0.0005 ROUTDC=0.006 VDO=1.1 IDO=0.8 IQ=5m IQ1=0 ILIM=1.2 GM=50 FP1=2meg FP2=5meg TSD=165 THYS=20 RTH=60 CTH=0.05 TA=25 IFLOOR=0
Bvreg vreg gnd V=V(vnom_int)+{KLINE}*(V(vin,gnd)-{VINREF})-({ROUTDC}-1/{GM})*V(ipas,gnd)
Vn vnom_int gnd {VNOM}
Bdem dem gnd V={GM}*(V(vreg,gnd)-V(vout,gnd))
R1 dem d1 1
C1 d1 gnd {1/(6.2831853*FP1)}
Eb d1b gnd d1 gnd 1
R2 d1b d2 1
C2 d2 gnd {1/(6.2831853*FP2)}
* thermal gate with hysteresis-free soft knee (no latch): g=1 below TSD-THYS... gate midpoint TSD, width 1 C
Bg g gnd V=0.5*(1-tanh((V(tj,gnd)-{TSD})/1))
* clamps (all in amps; soft minimum/maximum with eps 1m)
* x1 = softmin(demand, ILIM); y = dropout current; ipas = softmax(IFLOOR, softmin(x1,y)) * thermal gate  (soft width ~2 mA)
Bx1 x1 gnd V=0.5*(V(d2,gnd)+{ILIM}-sqrt((V(d2,gnd)-{ILIM})**2+4e-6))
By1 y1 gnd V=(V(vin,gnd)-V(vout,gnd))/({VDO}/{IDO})
Bx2 x2 gnd V=0.5*(V(x1,gnd)+V(y1,gnd)-sqrt((V(x1,gnd)-V(y1,gnd))**2+4e-6))
Bipas ipas gnd V=(0.5*(V(x2,gnd)+{IFLOOR}+sqrt((V(x2,gnd)-{IFLOOR})**2+4e-6)))*V(g,gnd)
Rdum ipas gnd 1G
Gp vin vout cur='V(ipas,gnd)'
* ground (quiescent) current
Gq vin gnd cur='{IQ}+{IQ1}*V(ipas,gnd)'
* power -> thermal node
Gpw gnd tj cur='min(max(V(vin,vout),0),V(vin,gnd))*V(ipas,gnd)+V(vin,gnd)*({IQ}+{IQ1}*V(ipas,gnd))'
Rth tj ta {RTH}
Cth tj ta {CTH}
Vta ta gnd {TA}
Dbody vout vin DREV
.model DREV D(IS=1e-12 N=1.5 RS=0.3)
.ends

Vin vin 0 5
X1 vin vout 0 LDO_R6 VNOM=3.3 VINREF=5 KLINE=0.0005 ROUTDC=0.006 VDO=1.1 IDO=0.8 IQ=5m ILIM=1.2 GM=40 FP1=200k FP2=2meg RTH=61.6
Iload vout 0 pwl(0 0.1 20u 0.1 21u 0.8 80u 0.8)
Cout vout co1 22u
Resr co1 0 0.3
* second regulator copy with low ESR
X2 vin vout2 0 LDO_R6 VNOM=3.3 VINREF=5 KLINE=0.0005 ROUTDC=0.006 VDO=1.1 IDO=0.8 IQ=5m ILIM=1.2 GM=40 FP1=200k FP2=2meg RTH=61.6
Iload2 vout2 0 pwl(0 0.1 20u 0.1 21u 0.8 80u 0.8)
Cout2 vout2 co2 22u
Resr2 co2 0 0.01
.nodeset v(vout)=3.3 v(vout2)=3.3
.tran 0.05u 80u
.control
set noaskquit
run
meas tran vmin1 min v(vout) from=20u to=80u
meas tran vmin2 min v(vout2) from=20u to=80u
meas tran vfin1 find v(vout) at=79u
meas tran vfin2 find v(vout2) at=79u
meas tran vmax2 max v(vout2) from=22u to=80u
meas tran vpre1 avg v(vout) from=10u to=19u
meas tran vpre2 avg v(vout2) from=10u to=19u
let under1_mv = (vpre1-vmin1)*1000
let under2_mv = (vpre2-vmin2)*1000
let vfin1_v = vfin1
let vfin2_v = vfin2
print under1_mv under2_mv vfin1_v vfin2_v
quit
.endc
.end
