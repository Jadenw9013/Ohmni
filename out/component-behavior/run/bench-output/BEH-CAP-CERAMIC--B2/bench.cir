B2 MLCC impedance, ESR/ESL, self-resonant frequency
* 10uF, ESR 5 mohm, ESL 0.7 nH, no bias. f0 = 1/(2 pi sqrt(L C)) = 1.9023 MHz, |Z|min = ESR
* OHMNI BEH-CAP-CERAMIC subcircuit, behavioural_approximation
* ports: p n flag ; flag node voltage is a bitmask: 1=overvoltage, 2=reverse(not used for ceramic)
.subckt ohm_mlcc p n flag params: C0=1u V0=1e6 ESR=5m ESL=0.7n RLK=1e9 VR=10 AGE=0 TCDEV=0
Lesl p a {ESL}
Resr a b {ESR}
* charge-based DC-bias capacitor: q = Ceff0*V0*atan(v/V0) so dq/dv = Ceff0/(1+(v/V0)^2)
Cb b n q = '{C0*(1-AGE)*(1+TCDEV)}*{V0}*atan(v(b,n)/{V0})'
Rlk b n {RLK}
Bflag flag 0 V = 'abs(v(b,n)) > {VR} ? 1 : 0'
.ends

Iac 0 p dc 0 ac 1
Xc p 0 f ohm_mlcc C0=10u V0=1e6 ESR=5m ESL=0.7n RLK=1e12 VR=100
Rf f 0 1meg
.ac dec 400 1k 100meg
.control
run
let zm = vm(p)
meas ac zmin min zm
meas ac fres when zm=zmin
meas ac zhf find zm at=100meg
echo f0_expected=1.9024meg
quit
.endc
.end
