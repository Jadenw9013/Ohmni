* BEH-IC-PKGBIND B2: Tj = Ta + P*thetaJA for the same ULN2003A dissipation in three packages, plus Pmax check.
* v2: removed the vector 'print' (tj1/tj2/tj3 were also node names/duplicate prints); scalars printed as 'name = value'; circuit unchanged
* thetaJA (TI SLRS027T): N PDIP-16 66.7, D SOIC-16 88.6, PW TSSOP-16 114.1 degC/W. Ta = 50 C. P = 0.60 W.
* Thermal analog: 1 W = 1 A, 1 degC = 1 V.  Expected Tj: 50+0.6*66.7=90.02 ; 50+0.6*88.6=103.16 ; 50+0.6*114.1=118.46
* Pmax(Ta=50,Tjmax=150) = 100/theta : 1.499 W / 1.129 W / 0.876 W
Vta ta 0 50
Ip1 0 tj1 0.6
Rth1 tj1 ta 66.7
Ip2 0 tj2 0.6
Rth2 tj2 ta 88.6
Ip3 0 tj3 0.6
Rth3 tj3 ta 114.1
.op
.control
set noaskquit
op
let tj1 = v(tj1)
let tj2 = v(tj2)
let tj3 = v(tj3)
let pm1 = (150-50)/66.7
let pm2 = (150-50)/88.6
let pm3 = (150-50)/114.1
let tjdip = v(tj1)
let tjsoic = v(tj2)
let tjtssop = v(tj3)
echo tj_dip_c = $&tjdip
echo tj_soic_c = $&tjsoic
echo tj_tssop_c = $&tjtssop
echo pmax_dip_w = $&pm1
echo pmax_soic_w = $&pm2
echo pmax_tssop_w = $&pm3
quit
.endc
.end
