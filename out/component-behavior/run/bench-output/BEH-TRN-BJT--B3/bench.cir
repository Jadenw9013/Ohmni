* BEH-TRN-BJT B3: DC current gain of the fitted models inside the datasheet hFE bands
* v2: absolute include path made relative; meas scalars (a100u..a100m) already print plain
* 2N3904 (onsemi 2N3903/D Rev 9, Vce=1 V): Ic 0.1mA 40-300, 1mA 70-300, 10mA 100-300, 50mA 60-300, 100mA 30-300
* Expected: every measured hFE lies inside its band. Tolerance: inside band (hard limits).
* OHMNI R6 BJT models fitted to onsemi datasheet bands (see parts/R6.md, BEH-TRN-BJT section 4)
* fidelity: behavioural_approximation. NOT a vendor model. Basis: ngspice Gummel-Poon fit to
* hFE min/max bands, Vce(sat), Vbe(sat), fT (datasheet), Cobo/Cibo (datasheet); VAF, BR, TR, XTB, XTI, EG are ASSUMPTIONs.
.model Q2N3904_R6FIT NPN(IS=1.4693e-14 BF=325.03 NF=1 VAF=100 IKF=0.061592 ISE=2.5511e-14 NE=1.331 BR=4 NR=1 RB=12.769 RE=1.1905 RC=1 CJE=9.4e-12 VJE=0.75 MJE=0.33 CJC=6.7e-12 VJC=0.75 MJC=0.33 TF=4.775e-10 XTF=2 ITF=0.4 VTF=4 TR=5e-08 XTB=1.5 EG=1.11 XTI=3)
.model Q2N2222A_R6FIT NPN(IS=3.2019e-14 BF=558.78 NF=1 VAF=100 IKF=0.21803 ISE=2.7068e-14 NE=1.2366 BR=4 NR=1 RB=6.6976 RE=0.097874 RC=0.56613 CJE=29e-12 VJE=0.75 MJE=0.33 CJC=17e-12 VJC=0.75 MJC=0.33 TF=4.608e-10 XTF=2 ITF=0.5 VTF=4 TR=6e-8 XTB=1.5 EG=1.11 XTI=3)

Qa ca ba 0 Q2N3904_R6FIT
Vca ca 0 1
Vba ba 0 0.6
.dc Vba 0.45 0.98 0.0025
.control
set noaskquit
run
let ica = -i(Vca)
let iba = -i(Vba)
let hfea = ica/iba
meas dc a100u find hfea when ica=100u
meas dc a1m find hfea when ica=1m
meas dc a10m find hfea when ica=10m
meas dc a50m find hfea when ica=50m
meas dc a100m find hfea when ica=100m
quit
.endc
.end
