* BEH-TRN-BJT B6: Vbe temperature coefficient of a diode-connected 2N3904 fit at I = 1 mA
* Analytic (ideal junction): dVbe/dT = (Vbe - Eg/q)/T - XTI*k/q
*   = (0.647 - 1.11)/300 - 3*8.617e-5 = -1.54e-3 - 0.26e-3 = -1.80 mV/K  (Eg=1.11, XTI=3 are model assumptions)
* Expected -1.8 mV/K, tolerance +/-0.3 mV/K
* OHMNI R6 BJT models fitted to onsemi datasheet bands (see parts/R6.md, BEH-TRN-BJT section 4)
* fidelity: behavioural_approximation. NOT a vendor model. Basis: ngspice Gummel-Poon fit to
* hFE min/max bands, Vce(sat), Vbe(sat), fT (datasheet), Cobo/Cibo (datasheet); VAF, BR, TR, XTB, XTI, EG are ASSUMPTIONs.
.model Q2N3904_R6FIT NPN(IS=1.4693e-14 BF=325.03 NF=1 VAF=100 IKF=0.061592 ISE=2.5511e-14 NE=1.331 BR=4 NR=1 RB=12.769 RE=1.1905 RC=1 CJE=9.4e-12 VJE=0.75 MJE=0.33 CJC=6.7e-12 VJC=0.75 MJC=0.33 TF=4.775e-10 XTF=2 ITF=0.4 VTF=4 TR=5e-08 XTB=1.5 EG=1.11 XTI=3)
.model Q2N2222A_R6FIT NPN(IS=3.2019e-14 BF=558.78 NF=1 VAF=100 IKF=0.21803 ISE=2.7068e-14 NE=1.2366 BR=4 NR=1 RB=6.6976 RE=0.097874 RC=0.56613 CJE=29e-12 VJE=0.75 MJE=0.33 CJC=17e-12 VJC=0.75 MJC=0.33 TF=4.608e-10 XTF=2 ITF=0.5 VTF=4 TR=6e-8 XTB=1.5 EG=1.11 XTI=3)

Q1 b b 0 Q2N3904_R6FIT
I1 0 b 1m
.control
set noaskquit
dc temp 25 75 50
let vb = v(b)
print vb
let tc = (vb[1]-vb[0])/50
print tc
quit
.endc
.end
