* BEH-TRN-BJT B1: 2N3904 saturated switch driving an LED
* 3.3 V logic -> Rb 1k -> base; collector: 5 V -> LED -> 220 ohm -> collector
* Analytic: Ic = (Vcc - Vf - Vce_sat)/R with Vf from diode eq. Vf=N*Vt*ln(Ic/Is)
*   N=2, Is=1e-19, Vt(27C)=0.025865  => Vf(13 mA)~2.03 V ; Vce(sat)~0.06 V (fit)
*   Ic_expected = (5-2.03-0.06)/220 = 13.2 mA  (tolerance 5 %)
*   forced beta = Ic/Ib ; Ib=(3.3-0.75)/1k=2.55 mA -> beta_forced ~5 (hard saturation)
* OHMNI R6 BJT models fitted to onsemi datasheet bands (see parts/R6.md, BEH-TRN-BJT section 4)
* fidelity: behavioural_approximation. NOT a vendor model. Basis: ngspice Gummel-Poon fit to
* hFE min/max bands, Vce(sat), Vbe(sat), fT (datasheet), Cobo/Cibo (datasheet); VAF, BR, TR, XTB, XTI, EG are ASSUMPTIONs.
.model Q2N3904_R6FIT NPN(IS=1.4693e-14 BF=325.03 NF=1 VAF=100 IKF=0.061592 ISE=2.5511e-14 NE=1.331 BR=4 NR=1 RB=12.769 RE=1.1905 RC=1 CJE=9.4e-12 VJE=0.75 MJE=0.33 CJC=6.7e-12 VJC=0.75 MJC=0.33 TF=4.775e-10 XTF=2 ITF=0.4 VTF=4 TR=5e-08 XTB=1.5 EG=1.11 XTI=3)
.model Q2N2222A_R6FIT NPN(IS=3.2019e-14 BF=558.78 NF=1 VAF=100 IKF=0.21803 ISE=2.7068e-14 NE=1.2366 BR=4 NR=1 RB=6.6976 RE=0.097874 RC=0.56613 CJE=29e-12 VJE=0.75 MJE=0.33 CJC=17e-12 VJC=0.75 MJC=0.33 TF=4.608e-10 XTF=2 ITF=0.5 VTF=4 TR=6e-8 XTB=1.5 EG=1.11 XTI=3)

.model LEDR D(IS=1e-19 N=2)
Vlogic in 0 3.3
Rb in b 1k
Q1 c b 0 Q2N3904_R6FIT
Vcc vcc 0 5
D1 vcc x LEDR
R1 x c 220
.control
set noaskquit
op
let ic = (v(x)-v(c))/220
print ic v(c) i(Vlogic)
quit
.endc
.end
