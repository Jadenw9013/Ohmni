* BEH-TRN-BJT B4: Vce(sat)/Vbe(sat) of the fits against datasheet limits
* v2: absolute include path made relative; printed named scalars vce_1..vce_3 and vbe_1..vbe_3 instead of v(c1) v(b1) ...
* 2N3904 (2N3903/D Rev 9): Ic=10mA/Ib=1mA Vce(sat)<=0.2 V, Vbe(sat) 0.65-0.85 V ; Ic=50mA/Ib=5mA Vce(sat)<=0.3 V, Vbe(sat) 0.85-0.95 V
* PN2222A (PN2222A/D Rev 1.1.0): Ic=150mA/Ib=15mA (Ib ASSUMED, standard forced beta 10) Vce(sat)<=0.3 V, Vbe(sat) 0.6-1.2 V
* Expected: each value inside its limit. Tolerance: hard limit.
* OHMNI R6 BJT models fitted to onsemi datasheet bands (see parts/R6.md, BEH-TRN-BJT section 4)
* fidelity: behavioural_approximation. NOT a vendor model. Basis: ngspice Gummel-Poon fit to
* hFE min/max bands, Vce(sat), Vbe(sat), fT (datasheet), Cobo/Cibo (datasheet); VAF, BR, TR, XTB, XTI, EG are ASSUMPTIONs.
.model Q2N3904_R6FIT NPN(IS=1.4693e-14 BF=325.03 NF=1 VAF=100 IKF=0.061592 ISE=2.5511e-14 NE=1.331 BR=4 NR=1 RB=12.769 RE=1.1905 RC=1 CJE=9.4e-12 VJE=0.75 MJE=0.33 CJC=6.7e-12 VJC=0.75 MJC=0.33 TF=4.775e-10 XTF=2 ITF=0.4 VTF=4 TR=5e-08 XTB=1.5 EG=1.11 XTI=3)
.model Q2N2222A_R6FIT NPN(IS=3.2019e-14 BF=558.78 NF=1 VAF=100 IKF=0.21803 ISE=2.7068e-14 NE=1.2366 BR=4 NR=1 RB=6.6976 RE=0.097874 RC=0.56613 CJE=29e-12 VJE=0.75 MJE=0.33 CJC=17e-12 VJC=0.75 MJC=0.33 TF=4.608e-10 XTF=2 ITF=0.5 VTF=4 TR=6e-8 XTB=1.5 EG=1.11 XTI=3)

Q1 c1 b1 0 Q2N3904_R6FIT
Ic1 0 c1 10m
Ib1 0 b1 1m
Q2 c2 b2 0 Q2N3904_R6FIT
Ic2 0 c2 50m
Ib2 0 b2 5m
Q3 c3 b3 0 Q2N2222A_R6FIT
Ic3 0 c3 150m
Ib3 0 b3 15m
.control
set noaskquit
op
let vce_1 = v(c1)
let vbe_1 = v(b1)
let vce_2 = v(c2)
let vbe_2 = v(b2)
let vce_3 = v(c3)
let vbe_3 = v(b3)
print vce_1 vbe_1 vce_2 vbe_2 vce_3 vbe_3
quit
.endc
.end
