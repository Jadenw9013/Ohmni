B4 self-heating steady state, XAL4020-222ME: DCR typ 35.2 mohm, Irms(40C rise)=5.5 A
* v2: RESULT echo replaced by scalar prints ind4_dt_5p5a, ind4_dt_2p75a, ind4_dt_6p6a (circuit unchanged)
* RTH = 40/(Irms^2*DCR*(1+TC*40)) = 32.4626 degC/W (DERIVED, assumes datasheet DCR is at 25C and rating test is self-consistent)
* Expected rise: dT = a/(1-a*TC), a = RTH*I^2*DCR : 40.0 @5.5A, 8.945 @2.75A, 61.88 @6.6A
* OHMNI BEH-MAG-INDUCTOR realistic model (behavioural_approximation)
* Pins: a b. Params: L0 [H], Isat [A] at inductance drop DROP, LR = Lsat/L0 floor,
* RDC [ohm], CP [F] (from SRF), RP [ohm] (parallel loss).
.subckt IND_SAT a b L0=1u Isat=5 DROP=0.3 LR=0.05 RDC=10m CP=1p RP=1e9
.param ia={Isat/atanh(sqrt(DROP/(1-LR)))}
Rdc a x {RDC}
Lnl x b L='L0*(LR+(1-LR)*(1/cosh(max(min(i(Lnl)/ia,20),-20)))**2)'
Cp a b {CP}
Rp a b {RP}
.ends

* Same model plus self-heating. Node th is the temperature rise in degC (1 V = 1 degC).
* RTH [degC/W], CTH [J/degC], TC copper tempco [1/degC].
.subckt IND_SAT_TH a b th L0=1u Isat=5 DROP=0.3 LR=0.05 RDC=10m CP=1p RP=1e9 RTH=40 CTH=0.05 TC=3.93m
.param ia={Isat/atanh(sqrt(DROP/(1-LR)))}
Rdc a x R='RDC*(1+TC*v(th))'
Lnl x b L='L0*(LR+(1-LR)*(1/cosh(max(min(i(Lnl)/ia,20),-20)))**2)'
Cp a b {CP}
Rp a b {RP}
Bpw 0 th I='v(a,x)*v(a,x)/(RDC*(1+TC*v(th)))'
Rth th 0 {RTH}
Cth th 0 {CTH}
.ends

I1 0 p DC 5.5
X1 p 0 th IND_SAT_TH L0=2.2u Isat=5.6 DROP=0.3 LR=0.05 RDC=35.2m CP=0.01p RP=1e12 RTH=32.4626 CTH=0.05 TC=3.93m
.control
foreach ik 5.5 2.75 6.6
 alter I1 dc = $ik
 op
 if $ik eq 5.5
  let ind4_dt_5p5a = v(th)
  print ind4_dt_5p5a
 end
 if $ik eq 2.75
  let ind4_dt_2p75a = v(th)
  print ind4_dt_2p75a
 end
 if $ik eq 6.6
  let ind4_dt_6p6a = v(th)
  print ind4_dt_6p6a
 end
end
quit
.endc
.end
