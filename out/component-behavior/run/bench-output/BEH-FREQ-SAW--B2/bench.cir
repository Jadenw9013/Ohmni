B2 SAW mismatch: same filter with 100 ohm load instead of 50 ohm (impedance-matching sensitivity). Midband n=3 Chebyshev is transparent so loss is that of the pad terminated in 100 ohm.
* v2: print renamed il -> il_100ohm_db; circuit unchanged
* OHMNI SAW band-pass L1 behavioural: lossless 3-pole Chebyshev (0.5 dB ripple) + matched pi attenuator for flat insertion loss; 50 ohm; generated by gen_saw_R8.py
* f0=869000000.0 bw(passband, ripple edges)=8000000.0 il_db=4.5 (pad Rshunt=197.3179 Rseries=27.0785)
.subckt ohm_saw in out gnd
Rp1 in gnd 1.973179e+02
Rps in p2 2.707855e+01
Rp2 p2 gnd 1.973179e+02
Ls1 p2 a1 1.587869e-06
Cs1 a1 n1 2.112448e-14
Lp n1 gnd 7.686926e-11
Cp n1 gnd 4.363631e-10
Ls3 n1 c1 1.587869e-06
Cs3 c1 out 2.112448e-14
.ends ohm_saw

V1 s 0 ac 1
Rs s in 50
X1 in out 0 ohm_saw
Rl out 0 100
.control
ac lin 1 869e6 869e6
let il_100ohm_db = -10*log10(4*50*mag(v(out))^2/100)
print il_100ohm_db
quit
.endc
.end
