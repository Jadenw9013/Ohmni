* BEH-IC-DRIVER-DIP16 B1: ULN2003A VCE(sat) at the three TI SLRS027T test points (base current forced with rb=1 mohm and a current source).
* v2: scalars printed as 'name = value'; behavior unchanged
* TI bands: 0.9..1.1 V @ IC=100 mA, II=250 uA ; 1.0..1.3 V @ 200 mA, 350 uA ; 1.2..1.6 V @ 350 mA, 500 uA. Fit targets (band mid): 0.99 / 1.15 / 1.40 V
* BEH-IC-DRIVER-DIP16: ULN2003A Darlington channel (Gummel-Poon, fitted) and L293D half-H channel (behavioural). ngspice 42 stock.
* ---- ULN2003A one channel: pins in out com e   (package pins: 1B..7B = 1..7, E = 8, COM = 9, 7C..1C = 10..16) ----
* Topology: input 2.7k (TI SLRS027T block diagram), Darlington Q1/Q2, 3k base pulldown (ASSUMED, from schematic memory not confirmed in the extract), output clamp diode out->com.
* Q1/Q2 parameters fitted by bench/ic-driver/fit_uln.py to the middle of the datasheet VCE(sat) bands: (0.1 A, 250 uA) 0.9..1.1 V ; (0.2 A, 350 uA) 1.0..1.3 V ; (0.35 A, 500 uA) 1.2..1.6 V.
.model q1uln npn(is=1e-14 bf=50 vaf=100 rb=20 rc=2 re=0 ikf=0.05 cje=5p cjc=3p tf=0.5n tr=50n)
.model q2uln npn(is=1e-13 bf=100 vaf=100 rb=3 rc=0.3 re=1.5 ikf=0.5 cje=20p cjc=10p tf=1n tr=100n)
.model duln d(is=1e-11 n=1 rs=3.4 cjo=10p tt=100n bv=60 ibv=10u)
.subckt uln_ch in out com e params: rb=2.7k
Rb in b1 {rb}
Q1 out b1 b2 q1uln
Q2 out b2 e q2uln
R3 b2 e 3k
Dcl out com duln
.ends
* ---- L293D one half-H channel: pins a en y vcc1 vcc2 gnd (logic in, enable, output, logic supply, motor supply, ground) ----
* Output: Thevenin to VCC2 (roh, high) or GND (rol, low) when enabled and VCC1 present; Hi-Z otherwise. Roh/Rol are LINEAR fits to one datasheet point each (VOH=VCC2-1.4..1.8 V and VOL=1.2..1.8 V at 1 A, mid values) -> L confidence.
* Clamp diodes (L293D only) to VCC2 and GND, VF ~1.3 V typ at high current (extract).
.model dl293 d(is=1e-10 n=1.5 rs=0.8 cjo=20p)
.subckt l293d_ch a en y vcc1 vcc2 gnd params: roh=1.6 rol=1.5 vih=2.3 vil=1.5
Bs s gnd V=0.5*(1+tanh((v(a)-0.5*({vih}+{vil}))/0.1))
Be e1 gnd V=0.5*(1+tanh((v(en)-0.5*({vih}+{vil}))/0.1))*0.5*(1+tanh((v(vcc1)-4.5)/0.1))
Bth y gnd I=v(e1)*(v(y)-(v(gnd)+v(s)*(v(vcc2)-v(gnd))))/(roh*v(s)+rol*(1-v(s)))
Bsup vcc2 gnd I=v(e1)*max(((v(gnd)+v(s)*(v(vcc2)-v(gnd)))-v(y))/(roh*v(s)+rol*(1-v(s))),0)
Dh y vcc2 dl293
Dl gnd y dl293
Rleak y gnd 1e9
.ends

Vc vcc 0 5
Ia 0 ina dc 250u
Xa ina outa vcc 0 uln_ch rb=1m
Ica vcc outa dc 100m
Ib 0 inb dc 350u
Xb inb outb vcc 0 uln_ch rb=1m
Icb vcc outb dc 200m
Ic3 0 inc dc 500u
Xc inc outc vcc 0 uln_ch rb=1m
Icc vcc outc dc 350m
.control
set noaskquit
op
let va = v(outa)
let vb = v(outb)
let vc = v(outc)
echo vce_100ma_v = $&va
echo vce_200ma_v = $&vb
echo vce_350ma_v = $&vc
quit
.endc
.end
