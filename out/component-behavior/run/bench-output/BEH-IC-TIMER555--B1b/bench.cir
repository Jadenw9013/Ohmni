* BEH-IC-TIMER555 B1b: astable with large R1 (Ron effect negligible). R1=10k R2=100k C=1 nF, Vcc=5 V.
* v2: scalars printed as 'name = value'; behavior unchanged
* Analytic (TI SLFS022K): f = 1.44/((R1+2R2)C) = 1.44/(210k*1n) = 6857 Hz ; tH = 0.693*110k*1n = 76.2 us ; tL = 0.693*100k*1n = 69.3 us ; duty = 110/210 = 52.38 %
* Exact ideal-comparator: f = 1/(ln2*210k*1n) = 6870 Hz. Ron=30 ohm vs R1=10k: Vd=15 mV, effect < 0.2 %.
* BEH-IC-TIMER555 behavioural 555 (behavioural_approximation). ngspice 42 stock, no XSPICE.
* pins: gnd trig out rst cont thr dis vcc   (= DIP-8/SOIC-8/TSSOP-8 pins 1..8 in this order)
* Internal 3x5k divider (CONT = 2/3 Vcc open circuit). Threshold comparator trips at v(cont); trigger comparator at v(cont)/2.
* SR latch state q (1 = OUT high): dq/dt = k*( set*(1-reset)*(1-q) - reset*q ), reset dominant (also forced by RESET < 0.7 V: threshold ASSUMED, see class text)
* Output: Thevenin (vcc - voh0) / 0 behind rout (fit to TI SLFS022K points, see class text). Discharge: switch to gnd with ron when q=0.
.subckt ne555 gnd trig out rst cont thr dis vcc params: rdiv=5k voh0=0.9 rout=8 ron=30 ithr=100n itrg=500n klatch=1e8 rstth=0.7 icc0=2m icck=0.7m
Rd1 vcc cont {rdiv}
Rd2 cont nlo {rdiv}
Rd3 nlo gnd {rdiv}
* comparator decisions (smooth 1 mV edges)
Bset sset gnd V=0.5*(1+tanh((v(nlo)-v(trig))/0.001))
Brst srst gnd V=max(0.5*(1+tanh((v(thr)-v(cont))/0.001)), 0.5*(1+tanh((rstth-v(rst))/0.001)))
* latch (1 F cap so I = dq/dt)
Cq q gnd 1 ic=0
Bq gnd q I={klatch*( v(sset)*(1-v(srst))*(1-v(q)) - v(srst)*v(q) )}
Rq q gnd 1e12
* output stage
Bout oi gnd V=v(q)*(v(vcc)-v(gnd)-voh0)+v(gnd)
Ro oi out {rout}
* discharge transistor
Bdc dc gnd V=1-v(q)
Sdis dis gnd dc gnd swd
.model swd sw vt=0.5 vh=0.1 ron={ron} roff=100Meg
* input currents (THRES sinks, TRIG sources) and supply current
Ith thr gnd dc {ithr}
Itg trig gnd dc {-itrg}
Bicc vcc gnd I={icc0 + icck*(v(vcc)-v(gnd)-5) - 1m*(1-v(q))*0 }
.ends

Vcc vcc 0 5
X1 0 trig out vcc cnt trig dis vcc ne555
Cc cnt 0 10n
R1 vcc dis 10k
R2 dis trig 100k
C1 trig 0 1n
.tran 20n 4m uic
.control
set noaskquit
run
meas tran t1 when v(out)=2.5 rise=3
meas tran t2 when v(out)=2.5 rise=4
meas tran tf when v(out)=2.5 fall=3
let per = t2-t1
let f = 1/per
let duty = (tf-t1)/per
let per_us = per*1e6
echo f_b1b_hz = $&f
echo period_b1b_us = $&per_us
echo duty_b1b = $&duty
quit
.endc
.end
