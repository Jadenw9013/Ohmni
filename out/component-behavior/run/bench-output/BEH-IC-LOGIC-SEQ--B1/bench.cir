* BEH-IC-LOGIC-SEQ B1: 74HC595 shift/latch/OE behaviour. Vcc=4.5 V, SRCLK 5 MHz (< fmax 21..31 MHz @4.5 V, SCLS041J extract).
* v2: QA..QH latched levels packed into one integer scalar qa_qh_word (bit0=QA..bit7=QH, threshold Vcc/2) and printed as 'name = value'; behavior unchanged
* Data in (first..last) = 1,0,1,1,0,0,1,0 -> after 8 SRCLK edges: QH=1 QG=0 QF=1 QE=1 QD=0 QC=0 QB=1 QA=0 ; QA..QH =0,1,0,0,1,1,0,1 after RCLK.
* Expectations: before RCLK all Q=0; after RCLK Q per above; QH' (unlatched serial out) = QH of the shift register; OE high -> outputs Hi-Z (pulled to mid by 10k/10k divider -> 2.25 V)
* BEH-IC-LOGIC-SEQ: 74HC595 and 74HC138 L2 models. Needs XSPICE (adc_bridge, dac_bridge, d_dff, d_inverter): ngspice 42 here is built with XSPICE.
* Pin order of every subckt = DIP/SOIC/TSSOP package pin order 1..N, so X-instances can be bound pin-for-pin.
.model dclamp d(is=1e-14 n=1 rs=5 cjo=0)
.model adcn adc_bridge(in_low=0.4 in_high=0.6 rise_delay=1n fall_delay=1n)
.model dacn dac_bridge(out_low=0 out_high=1 out_undef=0.5 t_rise=1n t_fall=1n)
.model dffm d_dff(clk_delay=12n set_delay=12n reset_delay=12n ic=0)
.model dinv d_inverter(rise_delay=1n fall_delay=1n)
* ---- input conditioner: Ci, ESD clamps, normalised decision (0..1) at Vcc/2 ----
.subckt hcin a n vcc gnd params: ci=5p
Cia a gnd {ci}
Dah a vcc dclamp
Dal gnd a dclamp
Bn n gnd V=0.5*(1+tanh((v(a)-(v(gnd)+0.5*(v(vcc)-v(gnd))))/0.05))
.ends
* ---- output cell: normalised s (0..1) + normalised enable en (1 = driven). Thevenin roh/rol, hi-Z leakage when en=0 ----
.subckt hcout s en y vcc gnd params: roh=50 rol=65 td=10.4n taue=6.4n gz=1n
Bsd0 sdd gnd V=min(max(v(s),0),1)
Rsd sdd d2 50
T1 d2 gnd d3 gnd Z0=50 TD={td}
Rtd d3 gnd 50
Bsh sh gnd V=2*v(d3)
Rsh sh sh2 {taue/1p}
Csh sh2 gnd 1p
Bth y gnd I=min(max(v(en),0),1)*(v(y)-(v(gnd)+min(max(v(sh2),0),1)*(v(vcc)-v(gnd))))/(roh*min(max(v(sh2),0),1)+rol*(1-min(max(v(sh2),0),1)))+(1-min(max(v(en),0),1))*gz*(v(y)-v(gnd))
Bsup vcc gnd I=min(max(v(en),0),1)*max(((v(gnd)+min(max(v(sh2),0),1)*(v(vcc)-v(gnd)))-v(y))/(roh*min(max(v(sh2),0),1)+rol*(1-min(max(v(sh2),0),1))),0)
Dyh y vcc dclamp
Dyl gnd y dclamp
.ends
* ---- 74HC595 : pins 1..16 = QB QC QD QE QF QG QH GND QH' SRCLR SRCLK RCLK OE SER QA VCC ----
.subckt hc595 qb qc qd qe qf qg qh gnd qhp srclr srclk rclk oe ser qa vcc params: cpd=400p icc0=8u
Xi1 srclr n_clr vcc gnd hcin
Xi2 srclk n_sck vcc gnd hcin
Xi3 rclk n_rck vcc gnd hcin
Xi4 oe n_oe vcc gnd hcin
Xi5 ser n_ser vcc gnd hcin
Aadc [n_clr n_sck n_rck n_ser n_oe] [d_clr d_sck d_rck d_ser d_oe] adcn
Ainv d_clr d_rst dinv
* shift register: stage1 = QA ... stage8 = QH
Asr1 d_ser d_sck NULL d_rst sr1 nsr1 dffm
Asr2 sr1 d_sck NULL d_rst sr2 nsr2 dffm
Asr3 sr2 d_sck NULL d_rst sr3 nsr3 dffm
Asr4 sr3 d_sck NULL d_rst sr4 nsr4 dffm
Asr5 sr4 d_sck NULL d_rst sr5 nsr5 dffm
Asr6 sr5 d_sck NULL d_rst sr6 nsr6 dffm
Asr7 sr6 d_sck NULL d_rst sr7 nsr7 dffm
Asr8 sr7 d_sck NULL d_rst sr8 nsr8 dffm
* storage register
Ast1 sr1 d_rck NULL NULL st1 nst1 dffm
Ast2 sr2 d_rck NULL NULL st2 nst2 dffm
Ast3 sr3 d_rck NULL NULL st3 nst3 dffm
Ast4 sr4 d_rck NULL NULL st4 nst4 dffm
Ast5 sr5 d_rck NULL NULL st5 nst5 dffm
Ast6 sr6 d_rck NULL NULL st6 nst6 dffm
Ast7 sr7 d_rck NULL NULL st7 nst7 dffm
Ast8 sr8 d_rck NULL NULL st8 nst8 dffm
Ainvoe d_oe d_oen dinv
Adac [st1 st2 st3 st4 st5 st6 st7 st8 sr8 d_oen] [a_s1 a_s2 a_s3 a_s4 a_s5 a_s6 a_s7 a_s8 a_s9 a_oen] dacn
* OE is active low: enable = NOT OE
Xo1 a_s1 a_oen qa vcc gnd hcout
Xo2 a_s2 a_oen qb vcc gnd hcout
Xo3 a_s3 a_oen qc vcc gnd hcout
Xo4 a_s4 a_oen qd vcc gnd hcout
Xo5 a_s5 a_oen qe vcc gnd hcout
Xo6 a_s6 a_oen qf vcc gnd hcout
Xo7 a_s7 a_oen qg vcc gnd hcout
Xo8 a_s8 a_oen qh vcc gnd hcout
Bone one gnd V=1
Xo9 a_s9 one qhp vcc gnd hcout
Bicc vcc gnd I={icc0}+0.5*cpd*(v(vcc)-v(gnd))*(abs(ddt(v(n_sck)))+abs(ddt(v(n_rck))))*0.5
.ends
* ---- 74HC138 : pins 1..16 = A B C G2A G2B G1 Y7 GND Y6 Y5 Y4 Y3 Y2 Y1 Y0 VCC ----
.subckt hc138 a b c g2a g2b g1 y7 gnd y6 y5 y4 y3 y2 y1 y0 vcc params: cpd=85p icc0=8u
Xa a na vcc gnd hcin
Xb b nb vcc gnd hcin
Xc c nc vcc gnd hcin
Xg1 g1 ng1 vcc gnd hcin
Xg2a g2a ng2a vcc gnd hcin
Xg2b g2b ng2b vcc gnd hcin
Ben en gnd V=v(ng1)*(1-v(ng2a))*(1-v(ng2b))
Bone one gnd V=1
* active-low outputs: Yn = 1 - en*match(n)
By0 l0 gnd V=1-v(en)*(1-v(na))*(1-v(nb))*(1-v(nc))
By1 l1 gnd V=1-v(en)*(v(na))*(1-v(nb))*(1-v(nc))
By2 l2 gnd V=1-v(en)*(1-v(na))*(v(nb))*(1-v(nc))
By3 l3 gnd V=1-v(en)*(v(na))*(v(nb))*(1-v(nc))
By4 l4 gnd V=1-v(en)*(1-v(na))*(1-v(nb))*(v(nc))
By5 l5 gnd V=1-v(en)*(v(na))*(1-v(nb))*(v(nc))
By6 l6 gnd V=1-v(en)*(1-v(na))*(v(nb))*(v(nc))
By7 l7 gnd V=1-v(en)*(v(na))*(v(nb))*(v(nc))
Xo0 l0 one y0 vcc gnd hcout
Xo1 l1 one y1 vcc gnd hcout
Xo2 l2 one y2 vcc gnd hcout
Xo3 l3 one y3 vcc gnd hcout
Xo4 l4 one y4 vcc gnd hcout
Xo5 l5 one y5 vcc gnd hcout
Xo6 l6 one y6 vcc gnd hcout
Xo7 l7 one y7 vcc gnd hcout
Bicc vcc gnd I={icc0}
.ends

Vcc vcc 0 4.5
Vser ser 0 pwl(0n 0.0 50n 0.0 52n 4.5 250n 4.5 252n 0.0 450n 0.0 452n 4.5 650n 4.5 652n 4.5 850n 4.5 852n 0.0 1050n 0.0 1052n 0.0 1250n 0.0 1252n 4.5 1450n 4.5 1452n 0.0)
Vsck srclk 0 pwl(0 0 150n 0 152n 4.5 250n 4.5 252n 0 350n 0 352n 4.5 450n 4.5 452n 0 550n 0 552n 4.5 650n 4.5 652n 0 750n 0 752n 4.5 850n 4.5 852n 0 950n 0 952n 4.5 1050n 4.5 1052n 0 1150n 0 1152n 4.5 1250n 4.5 1252n 0 1350n 0 1352n 4.5 1450n 4.5 1452n 0 1550n 0 1552n 4.5 1650n 4.5 1652n 0)
Vclr srclr 0 pwl(0 0 20n 0 22n 4.5)
Vrck rclk 0 pwl(0 0 1900n 0 1902n 4.5 1960n 4.5 1962n 0)
Voe oe 0 pwl(0 0 2500n 0 2502n 4.5)
X1 qb qc qd qe qf qg qh 0 qhp srclr srclk rclk oe ser qa vcc hc595
Rp1 qa 0 10k
Rp2 qb 0 10k
Rp3 qc 0 10k
Rp4 qd 0 10k
Rp5 qe 0 10k
Rp6 qf 0 10k
Rp7 qg 0 10k
Rp8 qh 0 10k
Ru1 qa vcc 10k
Ru2 qb vcc 10k
Ru3 qc vcc 10k
Ru4 qd vcc 10k
Ru5 qe vcc 10k
Ru6 qf vcc 10k
Ru7 qg vcc 10k
Ru8 qh vcc 10k
.tran 1n 3200n
.control
set noaskquit
run
* sample points: t=1800n (before RCLK), t=2400n (after RCLK, OE low), t=3000n (OE high)
meas tran qa_pre find v(qa) at=1800n
meas tran qh_pre find v(qh) at=1800n
meas tran qhp_end find v(qhp) at=1850n
meas tran qa_post find v(qa) at=2400n
meas tran qb_post find v(qb) at=2400n
meas tran qc_post find v(qc) at=2400n
meas tran qd_post find v(qd) at=2400n
meas tran qe_post find v(qe) at=2400n
meas tran qf_post find v(qf) at=2400n
meas tran qg_post find v(qg) at=2400n
meas tran qh_post find v(qh) at=2400n
meas tran qa_hz find v(qa) at=3100n
meas tran qb_hz find v(qb) at=3100n
meas tran qr trig v(rclk) val=2.25 rise=1 targ v(qb) val=2.25 rise=1
* packed latched word: bit0=QA ... bit7=QH, each bit = (V(Q) gt Vcc/2); expected QA..QH = 0,1,0,0,1,1,0,1 -> 2+16+32+128 = 178
let qword = (qa_post gt 2.25)*1 + (qb_post gt 2.25)*2 + (qc_post gt 2.25)*4 + (qd_post gt 2.25)*8 + (qe_post gt 2.25)*16 + (qf_post gt 2.25)*32 + (qg_post gt 2.25)*64 + (qh_post gt 2.25)*128
let qpre = (qa_pre gt 2.25)*1 + (qh_pre gt 2.25)*2
let qrc = qr*1e9
echo qa_qh_word = $&qword
echo q_pre_rclk_word = $&qpre
echo qa_hiz_v = $&qa_hz
echo qb_hiz_v = $&qb_hz
echo rclk_to_q_ns = $&qrc
quit
.endc
.end
