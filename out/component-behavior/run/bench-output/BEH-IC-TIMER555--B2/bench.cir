* BEH-IC-TIMER555 B2: monostable. R=10k, C=100 nF, Vcc=5 V, trigger pulse low for 20 us at t=100 us.
* v2: scalar printed as 'name = value' (width_b2_ms); behavior unchanged
* Analytic: t = RC*ln(3) = 1.0986 ms (TI quotes 1.1 RC)
* BEH-IC-TIMER555 behavioural 555 (behavioural_approximation). ngspice 42 stock, no XSPICE.
* pins: gnd trig out rst cont thr dis vcc   (= DIP-8/SOIC-8/TSSOP-8 pins 1..8 in this order)
* Internal 3x5k divider (CONT = 2/3 Vcc open circuit). Threshold comparator trips at v(cont); trigger comparator at v(cont)/2.
* SR latch state q (1 = OUT high): dq/dt = k*( set*(1-reset)*(1-q) - reset*q ), reset dominant (also forced by RESET < 0.7 V: threshold ASSUMED, see class text)
* Output: Thevenin (vcc - voh0) / 0 behind rout (fit to TI SLFS022K points, see class text). Discharge: switch to gnd with ron when q=0.
.subckt ne555 gnd trig out rst cont thr dis vcc params: rdiv=5k voh0=0.9 rout=8 ron=30 ithr=100n itrg=500n klatch=1e8 rstth=0.7 icc0=2m icck=0.7m
Rd1 vcc cont {rdiv}
Rd2 cont nlo {rdiv}
Rd3 nlo gnd {rdiv}
* comparator decisions (smooth 1 mV edges)
Bset sset gnd V=0.5*(1+tanh((v(nlo)-v(trig))/0.001))
Brst srst gnd V=max(0.5*(1+tanh((v(thr)-v(cont))/0.001)), 0.5*(1+tanh((rstth-v(rst))/0.001)))
* latch (1 F cap so I = dq/dt)
Cq q gnd 1 ic=0
Bq gnd q I={klatch*( v(sset)*(1-v(srst))*(1-v(q)) - v(srst)*v(q) )}
Rq q gnd 1e12
* output stage
Bout oi gnd V=v(q)*(v(vcc)-v(gnd)-voh0)+v(gnd)
Ro oi out {rout}
* discharge transistor
Bdc dc gnd V=1-v(q)
Sdis dis gnd dc gnd swd
.model swd sw vt=0.5 vh=0.1 ron={ron} roff=100Meg
* input currents (THRES sinks, TRIG sources) and supply current
Ith thr gnd dc {ithr}
Itg trig gnd dc {-itrg}
Bicc vcc gnd I={icc0 + icck*(v(vcc)-v(gnd)-5) - 1m*(1-v(q))*0 }
.ends

Vcc vcc 0 5
Vtr tg 0 pulse(5 0 100u 1u 1u 20u 5m)
X1 0 tg out vcc cnt thr dis vcc ne555
Cc cnt 0 10n
R1 vcc thr 10k
Dd thr dis dd
Rdis dis thr 1
C1 thr 0 100n
.model dd d(is=1e-14)
.tran 200n 4m uic
.control
set noaskquit
run
meas tran ta when v(out)=2.5 rise=1
meas tran tb when v(out)=2.5 fall=1
let w = (tb-ta)*1000
echo width_b2_ms = $&w
quit
.endc
.end
