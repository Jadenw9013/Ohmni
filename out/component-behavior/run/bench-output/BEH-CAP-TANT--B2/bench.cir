B2 Tantalum derating and reverse flags, VR=16 V
* MnO2 DER=0.5 -> flag bit1 when V > 8 V ; hard-fail bit 8 when V > 1.32*16 = 21.12 V ; reverse bit 2 when V < -0.03*16 = -0.48 V
* OHMNI BEH-CAP-TANT subcircuit (polarised molded tantalum, MnO2 or polymer), behavioural_approximation
* ports: p(+) n(-) flag. flag bitmask: 1 = V > VR*DER, 2 = reverse > VREVFR*VR, 4 = |i| > IPK, 8 = V > 1.32*VR (beyond KEMET surge test level, treat as failed)
* RLK from KEMET T543 max leakage 0.1*C[uF]*V[uV]... : RLK = 1/(LKF*1e-6*C_uF) with LKF = 0.1 (max spec) => ohm
.subckt ohm_tant p n flag params: C0=100u ESR=0.1 ESL=2.5n RLK=100k VR=16 DER=0.5 VREVFR=0.03 IPK=1e9
Lesl p a {ESL}
Resr a c {ESR}
Vsns c b 0
Cb b n {C0}
Rlk b n {RLK}
Bflag flag 0 V = '(v(b,n) > {VR*DER} ? 1 : 0) + (v(b,n) < -{VREVFR*VR} ? 2 : 0) + (abs(i(Vsns)) > {IPK} ? 4 : 0) + (v(b,n) > {1.32*VR} ? 8 : 0)'
.ends

Vs in 0 PWL(0 0 24 24)
Rs in p 1
Xc p 0 f ohm_tant C0=1u ESR=0.1 RLK=1e12 VR=16 DER=0.5
Rf f 0 1meg
.tran 0.01 24
.control
run
meas tran fl_at_7 find v(f) at=7
meas tran fl_at_10 find v(f) at=10
meas tran fl_at_23 find v(f) at=23
meas tran t_flag1 when v(f)=0.5 rise=1
meas tran t_flag8 when v(f)=8.5 rise=1
quit
.endc
.end
