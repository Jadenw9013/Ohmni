B2 leakage-inductance turn-off spike with NO snubber (Llk=2 uH = 2% of Lp, Coss+Cp lumped 220 pF = 200 pF Cds + 20 pF)
* v2 (REPIN-001): fb2_vdpk removed from print; its meas line already prints it once.
* v2: meas renamed fb2_* and printed as scalars (circuit unchanged)
* Expected: drain peak ~ Vin + Vor + Ipk*sqrt(Llk/C) (energy 1/2 Llk Ipk^2 dumped into C; WE design-considerations spike equation Vspike = Ipk*Llk/(Cp+Cds) is dimensionally inconsistent
*   as extracted, so the energy-balance form is used). Vin=48, Vor=(Vout+Vf)/N ~ 43-44 V, Ipk ~ 1.0 A (B1), sqrt(2e-6/220e-12)=95.3 ohm -> ~ 186 V ; tolerance 20%
* OHMNI BEH-MAG-XFMR models (behavioural_approximation). Pins: p1 p2 s1 s2 (p1 and s1 are dot terminals).
* LP = primary open-circuit inductance, N = Ns/Np, LLK = leakage seen at primary with secondary shorted.
* RP, RS winding DC resistances. CIW = interwinding capacitance (one lumped C p1-s1 / p2-s2 split).
* Linear coupled-inductor version (K element).
.subckt XFMR_K p1 p2 s1 s2 LP=1m N=1 LLK=1u RP=1m RS=1m CIW=1p
.param kk={sqrt(1-LLK/LP)}
Rp1 p1 pa {RP}
L1 pa p2 {LP}
L2 sa s2 {LP*N*N}
Rs1 s1 sa {RS}
K12 L1 L2 {kk}
Ciw1 p1 s1 {CIW/2}
Ciw2 p2 s2 {CIW/2}
.ends

* Saturating version: leakage Llk in series on primary side, nonlinear magnetizing inductance across an ideal transformer.
* ISATM = magnetizing current at which Lm has dropped by DROP (referred to primary). LR = Lsat/Lm floor.
.subckt XFMR_SAT p1 p2 s1 s2 LP=1m N=1 LLK=1u RP=1m RS=1m CIW=1p ISATM=1 DROP=0.3 LR=0.05
.param lmag={LP-LLK}
.param ia={ISATM/atanh(sqrt(DROP/(1-LR)))}
Rp1 p1 pa {RP}
Llk pa pb {LLK}
Lm pb p2 L='lmag*(LR+(1-LR)*(1/cosh(max(min(i(Lm)/ia,20),-20)))**2)'
* ideal transformer v(sx,s2)=N*v(pb,p2); current N*i(Vs) forced pb->p2
Es sx s2 pb p2 {N}
Vs sx sb 0
Fp pb p2 Vs {N}
Rs1 s1 sb {RS}
Ciw1 p1 s1 {CIW/2}
Ciw2 p2 s2 {CIW/2}
.ends

.model SW SW(Ron=5m Roff=1G Vt=2.5 Vh=0.1)
.model DSCH D(IS=1e-7 N=1.05 RS=20m CJO=50p)
Vin in 0 DC 48
Vg g 0 PULSE(0 5 0 5n 5n 2u 10u)
X1 in d 0 sa XFMR_SAT LP=100u N=0.5 LLK=2u RP=20m RS=40m CIW=10p ISATM=3 DROP=0.3 LR=0.05
S1 d 0 g 0 SW
Cds d 0 200p
D1 sa out DSCH
Co out 0 1u
RL out 0 100
.tran 100n 1.2m
.control
run
meas tran fb2_vdpk max v(d) from=1.0m to=1.2m
meas tran fb2_vout avg v(out) from=1.0m to=1.2m
meas tran fb2_ipk min i(Vin) from=1.0m to=1.2m
print fb2_vout fb2_ipk
quit
.endc
.end
