B2 saturation under volt-second step. Expected: V*t = lambda(i) = LR*L0*i + (1-LR)*L0*ia*tanh(i/ia)
* OHMNI BEH-MAG-INDUCTOR realistic model (behavioural_approximation)
* Pins: a b. Params: L0 [H], Isat [A] at inductance drop DROP, LR = Lsat/L0 floor,
* RDC [ohm], CP [F] (from SRF), RP [ohm] (parallel loss).
.subckt IND_SAT a b L0=1u Isat=5 DROP=0.3 LR=0.05 RDC=10m CP=1p RP=1e9
.param ia={Isat/atanh(sqrt(DROP/(1-LR)))}
Rdc a x {RDC}
Lnl x b L='L0*(LR+(1-LR)*(1/cosh(max(min(i(Lnl)/ia,20),-20)))**2)'
Cp a b {CP}
Rp a b {RP}
.ends

* Same model plus self-heating. Node th is the temperature rise in degC (1 V = 1 degC).
* RTH [degC/W], CTH [J/degC], TC copper tempco [1/degC].
.subckt IND_SAT_TH a b th L0=1u Isat=5 DROP=0.3 LR=0.05 RDC=10m CP=1p RP=1e9 RTH=40 CTH=0.05 TC=3.93m
.param ia={Isat/atanh(sqrt(DROP/(1-LR)))}
Rdc a x R='RDC*(1+TC*v(th))'
Lnl x b L='L0*(LR+(1-LR)*(1/cosh(max(min(i(Lnl)/ia,20),-20)))**2)'
Cp a b {CP}
Rp a b {RP}
Bpw 0 th I='v(a,x)*v(a,x)/(RDC*(1+TC*v(th)))'
Rth th 0 {RTH}
Cth th 0 {CTH}
.ends

V1 in 0 PWL(0 0 1n 10)
X1 in 0 IND_SAT L0=10u Isat=6 DROP=0.2 LR=0.05 RDC=1m CP=0.01p RP=1e12
.tran 10n 12u
.control
run
meas tran i_4u find i(V1) at=4u
meas tran i_8u find i(V1) at=8u
meas tran i_10u find i(V1) at=10u
quit
.endc
.end
