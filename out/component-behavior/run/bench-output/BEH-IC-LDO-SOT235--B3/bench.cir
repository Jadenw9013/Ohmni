* BEH-IC-LDO-SOT235 B3: self-heating and thermal limiting, SOT-23-5 (DDC) thetaJA = 235.9 degC/W (TI SLVSA00E extract). Vin = 5.5 V, resistive load 16.5 ohm (~200 mA).
* v2: scalars printed as 'name = value'; behavior unchanged
* (a) Ta=25: Pd = (Vin-Vout)*Iout + Vin*Ign  ->  Tj = Ta + 235.9*Pd. Check: Tj equals Ta + rth*Pd computed from the printed Vout, Iout (self consistency), expected ~129 C, below the 160 C limit.
* (b) Ta=70: the same dissipation would give Tj = 174 C > 160 C: the thermal limiter folds the current back so that Tj ~ 160 C (memoryless model; the real part cycles 160/140 C).
* BEH-IC-LDO-SOT235 behavioural LDO for the TLV700xx family (TLV70033 = 3.3 V). behavioural_approximation. ngspice 42 stock.
* pins: in gnd en out   (SOT-23-5 DDC order is IN=1 GND=2 EN=3 NC=4 OUT=5; the package binding maps these)
* Pass element = current source I = icl*tanh(Iraw/icl)*enable*(1-shutdown), Iraw = a*b/(a+b) with a=(Vreg-Vout)/rout (regulation branch) and b=(Vin-Vout)/rdo (dropout branch): soft knee, output impedance ~rout, dropout resistance ~rdo, current limit icl, cannot sink current. (Smooth form chosen because hard min() kinks made ngspice's op solve fail.)
* Thermal: Pd -> Rth_ja -> Ta; memoryless thermal limiter: output current scaled by (1 - 0.5*(1+tanh((Tj-tsd_hi)/2))). The real part has hysteresis (~160 C off, ~140 C on, TI SLVSA00E extract) - NOT modelled (a latch has no unique DC solution); the model regulates at ~tsd_hi (time-average of the real thermal cycling). cth is an ASSUMPTION.
.subckt tlv700 in gnd en out params: vnom=3.3 acc=0 rdo=0.86 rout=0.04 icl=0.43 iq=31u ign200=270u ven_hi=0.9 ven_lo=0.4 rth=235.9 ta=25 tsd_hi=160 cth=0.05
* enable (hysteretic latch not modelled; single threshold at the mean of ven_hi/ven_lo)
Ben enb gnd V=0.5*(1+tanh((v(en)-v(gnd)-0.5*({ven_hi}+{ven_lo}))/0.02))
* thermal network: temperature in volts (1 V = 1 degC)
Vta tamb gnd dc {ta}
Rth tj tamb {rth}
Cth tj tamb {cth} ic=0
Bpd gnd tj I=max((v(in)-v(out))*v(ip)+v(in)*v(enb)*(iq+(ign200-iq)*min(max(v(ip)/0.2,0),1)),0)
Bts ts gnd V=0.5*(1+tanh((v(tj)-{tsd_hi})/2))
* pass element
Bip ip gnd V=v(enb)*(1-v(ts))*{icl}*tanh( ( ((0.5*(({vnom}*(1+acc)-(v(out)-v(gnd)))+sqrt(({vnom}*(1+acc)-(v(out)-v(gnd)))*({vnom}*(1+acc)-(v(out)-v(gnd)))+1e-8)))/{rout}+1e-9)*((0.5*((v(in)-v(out))+sqrt((v(in)-v(out))*(v(in)-v(out))+1e-8)))/{rdo}+1e-9) / (((0.5*(({vnom}*(1+acc)-(v(out)-v(gnd)))+sqrt(({vnom}*(1+acc)-(v(out)-v(gnd)))*({vnom}*(1+acc)-(v(out)-v(gnd)))+1e-8)))/{rout}+1e-9)+((0.5*((v(in)-v(out))+sqrt((v(in)-v(out))*(v(in)-v(out))+1e-8)))/{rdo}+1e-9)) )/{icl} )
Rip ip gnd 1e9
Bpass in out I=v(ip)
* internal feedback divider load (ASSUMED 1 Mohm, ~3 uA): also gives the output node a conductance to ground
Rfb out gnd 1Meg
* ground / quiescent current
Biq in gnd I=v(enb)*(iq+(ign200-iq)*min(max(v(ip)/0.2,0),1))
.ends

Vin in 0 5.5
Ven en 0 5.5
X1 in 0 en out tlv700 ta=25
Rl out 0 16.5
.nodeset v(x1.tj)=100 v(out)=3.2
.control
set noaskquit
op
let io = v(out)/16.5
let pd = (5.5-v(out))*io + 5.5*(31u+(270u-31u)*io/0.2)
let tjc = 25 + 235.9*pd
let vo = v(out)
let tjm = v(x1.tj)
echo a_vout_v = $&vo
echo a_iout_a = $&io
echo a_pd_w = $&pd
echo tj_model_c = $&tjm
echo tj_check_c = $&tjc
quit
.endc
.end
