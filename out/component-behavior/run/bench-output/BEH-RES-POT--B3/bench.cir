* POT B3: audio (log) taper approximation f=(10^(k*pos)-1)/(10^k-1), k=1.505 gives f(0.5)=0.15 (ASSUMPTION curve, see class doc)
* Expected unloaded Vw at pos=0.5 with Vin=10: 1.500 V
.subckt POT3 A W B params: Rtot=10k pos=0.5 Rend=1 Rw=100m k=1.505
.param f={(10**(k*pos)-1)/(10**k-1)}
Rab1 A m {max(Rtot*(1-f),Rend)}
Rab2 m B {max(Rtot*f,Rend)}
Rwp m W {Rw}
.ends
Vin A 0 10
Xp A w 0 POT3 Rtot=10k pos=0.5 k=1.505
Rl w 0 1e12
.control
set noaskquit
op
print v(w)
quit
.endc
.end
