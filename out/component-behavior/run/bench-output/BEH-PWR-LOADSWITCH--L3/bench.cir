* BEH-PWR-LOADSWITCH L3: constant-current clamp on a hard short. NX5P3290 (WLCSP-16): RON = 35 mOhm typ, ILIM programmable 0.4 .. 3.3 A by a resistor on pin A3 (resistor-to-current mapping NOT captured: ILIM is a direct model parameter here).
* v2: scalars already printed; header only, circuit unchanged
* Analytic: short (1 mOhm) -> I = (5/0.035)/(1+(5/(0.035*1.5))^4)^0.25 = 1.4999 A ; below limit (load 5 ohm) I = 5/(5+0.035) = 0.993 A (slightly lower in the model near the knee: the clamp is already active at 0.66*ILIM).
* BEH-PWR-LOADSWITCH behavioural load switch / power switch (behavioural_approximation, not a vendor model)
* ports: vin vout gnd en(logic, >1.0 V on) ; params: RON (ohm), ILIM (A, constant-current clamp), VUV (V, UVLO rising threshold), TON (s, enable-to-full-on time constant), RQOD (ohm quick output discharge, 0 = none)
* Pass element: smooth clamp I = (Vd/RON)/(1+(Vd/(RON*ILIM))^4)^0.25 : linear RON below ~0.7*ILIM, constant ~ILIM above. Reverse current is NOT blocked (real parts with reverse-current protection need an extra diode).
* gating g in [0,1]: g = enable AND (vin > VUV), first-order lag TON.
.subckt LOADSW vin vout gnd en params: RON=0.079 ILIM=10 VUV=2.54 TON=10u RQOD=0
Bgt gt gnd V = 0.5*(1+tanh((v(en)-v(gnd)-1)/0.05))*0.5*(1+tanh((v(vin)-v(gnd)-VUV)/0.005))
Rg gt gs 1k
Cg gs gnd {TON/1k}
Bpass vin vout I = v(gs)*((v(vin)-v(vout))/RON)/pow(1+pow(abs(v(vin)-v(vout))/(RON*ILIM),4),0.25) + (1-v(gs))*(v(vin)-v(vout))*1n
.ends

Vin vin 0 5
Ven en 0 3.3
Xs vin vout 0 en LOADSW RON=0.035 ILIM=1.5 VUV=3.0 TON=1u
Rshort vout 0 1m
Xs2 vin vout2 0 en LOADSW RON=0.035 ILIM=1.5 VUV=3.0 TON=1u
Rok vout2 0 5
.op
.control
set noaskquit
op
let ishort = v(vout)/1m
let iok = v(vout2)/5
print ishort iok
quit
.endc
.end
