* B2: voltage-drive of a power LED (3.00 V source + 0.1 ohm) with the same electro-thermal iteration; shows why a current source is required:
* v2: added scalars i_ratio_hot_cold = ilist[7]/ilist[0], i_cold, i_hot, tj_final; iteration unchanged
* the same 0.7 A-class operating point drifts up with temperature (negative tempco => current grows). Rth_total 39 K/W, eta=0.30 (ASSUMPTIONs).
* XP-E2-class white power LED, parameters fitted at Tj=85 C to Cree XP-E2 Rev 8D Vf points (3.05 V @700 mA, 3.15 V @1000 mA), N=3 assumed.
* TNOM=85 so the card reproduces the datasheet points at Tj=85 C. Tempco set by EG (about -3 mV/K, ASSUMPTION).
.model LED_XPE2 D (IS=1.87e-14 N=3.0 RS=0.2233 CJO=300p VJ=1.0 M=0.33 BV=5 IBV=10u EG=3.9 XTI=3 TNOM=85)

V1 vs 0 DC 3.0
R1 vs a 0.1
D1 a 0 LED_XPE2
.control
let tj = 25
let k = 0
let ilist = unitvec(8)
while k < 8
  option temp = $&tj
  op
  let i = (3.0 - v(a))/0.1
  let ilist[k] = i
  let vf = v(a)
  let tj = 25 + 39*(1-0.30)*vf*i
  let k = k + 1
end
print ilist
let i_cold = ilist[0]
let i_hot = ilist[7]
let i_ratio_hot_cold = i_hot/i_cold
let tj_final = tj
print i_cold
print i_hot
print i_ratio_hot_cold
print tj_final
quit
.endc
.end
