* BEH-IC-DIGITAL-IO B2: (a) input decision regions, (b) internal pull-up (20..50 kohm, ATmega328P extract; 35k used), (c) SO-style tri-state with 25LC256-class limits.
* v2: scalars printed as 'name = value' lines; behavior unchanged
* (a) Vcc=5 V, VIL=0.3*Vcc=1.5 V, VIH=0.6*Vcc=3.0 V: input 1.0 V -> din=0, und=0 ; 2.2 V -> und=1 ; 4.0 V -> din=1, und=0
* (b) pad connected to 1 kohm to GND with the pull-up on and OE=0: pad = 5*1k/(35k+1k) = 0.1389 V
* (c) 25LC256 SO (VOL 0.4 V @ 2.1 mA @4.5 V -> rol = 190 ohm ; VOH Vcc-0.5 @ -0.4 mA -> roh = 1250 ohm), OE=0 (CS high): pad floats to the 10k pull-down value.
* BEH-IC-DIGITAL-IO: electrical interface of a digital pin of an MCU / serial EEPROM (L2 pad model; the firmware/protocol behaviour is L3 and NOT simulated).
* pad din dout oe vcc gnd : pad = package pin; dout/oe = normalised (0..1, as node voltages) data and output-enable from a higher layer; din = normalised receive level (0..1) + 'und' flag node
* Input: Cpin, leakage, ESD clamps to rails; decision regions VIL = vilf*Vcc, VIH = vihf*Vcc, 'und' = 1 between them (undefined input level -> simulator should flag).
* Output: push-pull Thevenin roh/rol, hi-Z with leakage when oe=0; optional pull-up (rpu) when pu=1 and oe=0.
.model dpad d(is=1e-14 n=1 rs=5)
.subckt dio_pin pad din und dout oe pu vcc gnd params: vilf=0.3 vihf=0.6 roh=40 rol=20 cpin=4p ileak=1u rpu=35k
Cp pad gnd {cpin}
Dh pad vcc dpad
Dl gnd pad dpad
Bleak pad gnd I=(1-v(oe))*{ileak}*tanh((v(pad)-v(gnd))/0.1)*0.0
Bin din gnd V=0.5*(1+tanh((v(pad)-(v(gnd)+0.5*({vilf}+{vihf})*(v(vcc)-v(gnd))))/(0.02*(v(vcc)-v(gnd)))))
Bun und gnd V=0.25*(1+tanh((v(pad)-(v(gnd)+{vilf}*(v(vcc)-v(gnd))))/0.05))*(1-tanh((v(pad)-(v(gnd)+{vihf}*(v(vcc)-v(gnd))))/0.05))
Bth pad gnd I=v(oe)*(v(pad)-(v(gnd)+v(dout)*(v(vcc)-v(gnd))))/({roh}*v(dout)+{rol}*(1-v(dout)))
Bsup vcc gnd I=v(oe)*max(((v(gnd)+v(dout)*(v(vcc)-v(gnd)))-v(pad))/({roh}*v(dout)+{rol}*(1-v(dout))),0)
Bpu vcc pad I=(1-v(oe))*v(pu)*(v(vcc)-v(pad))/{rpu}
.ends

Vcc vcc 0 5
Vz z 0 0
Vo1 one 0 1
Va1 pa1 0 1.0
X1 pa1 d1 u1 z z z vcc 0 dio_pin
Va2 pa2 0 2.2
X2 pa2 d2 u2 z z z vcc 0 dio_pin
Va3 pa3 0 4.0
X3 pa3 d3 u3 z z z vcc 0 dio_pin
Rg4 pa4 0 1k
X4 pa4 d4 u4 z z one vcc 0 dio_pin
* (c) EEPROM SO hi-Z with 10k pulldown, vs driven high
Rg5 pa5 0 10k
X5 pa5 d5 u5 one z z vcc 0 dio_pin params: vilf=0.3 vihf=0.7 roh=1250 rol=190
Rg6 pa6 0 10k
X6 pa6 d6 u6 one one z vcc 0 dio_pin params: vilf=0.3 vihf=0.7 roh=1250 rol=190
Rg7 pa7 0 10k
X7 pa7 d7 u7 z z z vcc 0 dio_pin params: vilf=0.3 vihf=0.7 roh=1250 rol=190
.control
set noaskquit
op
let d1v = v(d1)
let u1v = v(u1)
let d2v = v(d2)
let u2v = v(u2)
let d3v = v(d3)
let u3v = v(u3)
let pa4v = v(pa4)
let pa6v = v(pa6)
echo din_in1p0v_v = $&d1v
echo und_in1p0v_v = $&u1v
echo din_in2p2v_v = $&d2v
echo und_in2p2v_v = $&u2v
echo din_in4p0v_v = $&d3v
echo und_in4p0v_v = $&u3v
echo pullup_pad_v = $&pa4v
echo so_driven_high_10k_v = $&pa6v
quit
.endc
.end
