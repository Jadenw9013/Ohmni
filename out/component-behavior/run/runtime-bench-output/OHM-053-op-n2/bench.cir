OHMNI sourced behavior circuit
.options tnom=25
.temp 25
Iexcitation1 0 n1 DC 16
Rc1_p 0 c1_p 0.014999999999999999
Lc1_p c1_p 0 1.2e-05
Rc1_s n1 c1_s 0.012
Lc1_s c1_s 0 3.0000000000000001e-06
Rc1_a 0 c1_a 0.017999999999999999
Lc1_a c1_a 0 1.9200000000000003e-06
Kc1_ps Lc1_p Lc1_s 0.98319208025017502
Kc1_pa Lc1_p Lc1_a 0.98319208025017502
Kc1_sa Lc1_s Lc1_a 0.98319208025017502
.op
.print op
.end
