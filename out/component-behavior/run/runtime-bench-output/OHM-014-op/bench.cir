OHMNI sourced behavior circuit
.options tnom=25
.temp 25
Iexcitation1 0 n1 DC 10
Rc1 n1 0 0.0050000000000000001
.op
.print op
.end
