OHMNI sourced behavior circuit
.options tnom=25
.temp 25
Iexcitation1 0 n1 DC 0.34999999999999998
Dc1 n1 0 LED_XPE2_c1 temp=85
.model LED_XPE2_c1 D (IS=1.87e-14 N=3.0 RS=0.2233 CJO=300p VJ=1.0 M=0.33 BV=5 IBV=10u EG=3.9 XTI=3 TNOM=85)
.op
.print op
.end
