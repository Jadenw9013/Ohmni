OHMNI sourced behavior circuit
.options tnom=25
.temp 25
Iexcitation1 0 n1 DC 2.5
Rc1_tip n1 0 0.029999999999999999
Rc1_slv 0 0 0.029999999999999999
.op
.print op
.end
