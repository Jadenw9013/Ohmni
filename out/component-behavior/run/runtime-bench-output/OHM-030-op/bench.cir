OHMNI sourced behavior circuit
.options tnom=25
.temp 25
Iexcitation1 0 n1 DC 3.5249999999999996e-05
Cc1 n1 0 4.6999999999999997e-05
Rc1_lk n1 0 709219.85815602844
.op
.print op
.end
