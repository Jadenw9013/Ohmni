OHMNI sourced behavior circuit
.options tnom=25
.temp 25
Iexcitation1 0 n1 DC 0.25
Rc1_cA1 0 0 0.040000000000000001
Rc1_cA4 0 0 0.040000000000000001
Rc1_cA5 0 0 0.040000000000000001
Rc1_cA6 n1 0 0.040000000000000001
Rc1_cA7 0 0 0.040000000000000001
Rc1_cA8 0 0 0.040000000000000001
Rc1_cA9 0 0 0.040000000000000001
Rc1_cA12 0 0 0.040000000000000001
Rc1_cB1 0 0 0.040000000000000001
Rc1_cB4 0 0 0.040000000000000001
Rc1_cB5 0 0 0.040000000000000001
Rc1_cB6 0 0 0.040000000000000001
Rc1_cB7 0 0 0.040000000000000001
Rc1_cB8 0 0 0.040000000000000001
Rc1_cB9 0 0 0.040000000000000001
Rc1_cB12 0 0 0.040000000000000001
.op
.print op
.end
