OHMNI sourced behavior circuit
.options tnom=25
.temp 25
Iexcitation1 0 n1 DC 0.82999999999999996
Rc1_A 0 0 0.29999999999999999
Rc1_B n1 0 0.29999999999999999
.op
.print op
.end
