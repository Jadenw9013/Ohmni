OHMNI sourced behavior circuit
.options tnom=25
.temp 25
Iexcitation1 0 n1 DC 0 AC 0.0001
Xc1 n1 0 ohm_xtal L1=0.048043471929502646 C1=2.0600000000000003e-15 R1=50 C0=8.300000000000001e-13
* OHMNI BVD crystal subcircuit. Terminals: 1 2. Params: L1 (H), C1 (F), R1 (ohm), C0 (F)
.subckt ohm_xtal 1 2 L1=44m C1=9f R1=80 C0=3p
Lm 1 a {L1}
Cm a b {C1}
Rm b 2 {R1}
C0x 1 2 {C0}
.ends ohm_xtal

.control
set numdgt=15
op
echo OHMNI_AC_OP
print v(n1)
echo OHMNI_AC_POINT 0
ac lin 1 15998083.961831586 15998083.961831586
print real(frequency) real(v(n1)) imag(v(n1))
echo OHMNI_AC_POINT 1
ac lin 1 15998133.961831586 15998133.961831586
print real(frequency) real(v(n1)) imag(v(n1))
echo OHMNI_AC_POINT 2
ac lin 1 15998183.961831586 15998183.961831586
print real(frequency) real(v(n1)) imag(v(n1))
echo OHMNI_AC_POINT 3
ac lin 1 15999950 15999950
print real(frequency) real(v(n1)) imag(v(n1))
echo OHMNI_AC_POINT 4
ac lin 1 16000050 16000050
print real(frequency) real(v(n1)) imag(v(n1))
quit
.endc
.end
