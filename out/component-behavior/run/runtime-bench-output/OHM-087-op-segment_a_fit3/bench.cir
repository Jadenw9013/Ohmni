OHMNI sourced behavior circuit
.options tnom=25
.temp 25
Iexcitation1 0 n1 DC 0.030148999999999999
Dc1A n1 0 SEG_c1
Dc1B n2 0 SEG_c1
Dc1C n2 0 SEG_c1
Dc1D n2 0 SEG_c1
Dc1E n2 0 SEG_c1
Dc1F n2 0 SEG_c1
Dc1G n2 0 SEG_c1
Dc1DP n2 0 SEG_c1
.model SEG_c1 D (IS=4.2379999999999998e-14 N=3.0070000000000001 RS=0 CJO=30p VJ=1.0 M=0.33 TT=0 BV=15 IBV=10u EG=2.2 XTI=3)
.op
.print op
.end
