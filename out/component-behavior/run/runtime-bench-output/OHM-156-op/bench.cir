OHMNI sourced behavior circuit
.options tnom=25
.temp 25
Iexcitation1 0 n1 DC 3
Rc1_m1 n1 0 0.01
Rc1_m2 0 0 0.01
.op
.print op
.end
