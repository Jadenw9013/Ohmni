OHMNI sourced behavior circuit
.options tnom=25
.temp 25
Vsource2 n2 0 DC 0
Vsource3 n3 0 DC 3.6000000000000001
Vc1_pu c1_pu 0 DC 1
Xc1_NRST n1 c1_NRST_din c1_NRST_und 0 0 c1_pu n3 0 dio_pin cpin=4.9999999999999997e-12 rpu=40000 vihf=0.69999999999999996 vilf=0.29999999999999999
Xc1_PA0 n1 c1_PA0_din c1_PA0_und 0 0 0 n3 0 dio_pin_ft cpin=4.9999999999999997e-12 vihf=0.69999999999999996 vilf=0.29999999999999999
Xc1_PA1 n1 c1_PA1_din c1_PA1_und 0 0 0 n3 0 dio_pin_ft cpin=4.9999999999999997e-12 vihf=0.69999999999999996 vilf=0.29999999999999999
Xc1_PA10 n1 c1_PA10_din c1_PA10_und 0 0 0 n3 0 dio_pin_ft cpin=4.9999999999999997e-12 vihf=0.69999999999999996 vilf=0.29999999999999999
Xc1_PA11 n1 c1_PA11_din c1_PA11_und 0 0 0 n3 0 dio_pin_ft cpin=4.9999999999999997e-12 vihf=0.69999999999999996 vilf=0.29999999999999999
Xc1_PA12 n1 c1_PA12_din c1_PA12_und 0 0 0 n3 0 dio_pin_ft cpin=4.9999999999999997e-12 vihf=0.69999999999999996 vilf=0.29999999999999999
Xc1_PA2 n1 c1_PA2_din c1_PA2_und 0 0 0 n3 0 dio_pin_ft cpin=4.9999999999999997e-12 vihf=0.69999999999999996 vilf=0.29999999999999999
Xc1_PA3 n1 c1_PA3_din c1_PA3_und 0 0 0 n3 0 dio_pin_ft cpin=4.9999999999999997e-12 vihf=0.69999999999999996 vilf=0.29999999999999999
Xc1_PA4 n2 c1_PA4_din c1_PA4_und 0 0 0 n3 0 dio_pin cpin=4.9999999999999997e-12 vihf=0.69999999999999996 vilf=0.29999999999999999
Xc1_PA5 n1 c1_PA5_din c1_PA5_und 0 0 0 n3 0 dio_pin cpin=4.9999999999999997e-12 vihf=0.69999999999999996 vilf=0.29999999999999999
Xc1_PA6 n1 c1_PA6_din c1_PA6_und 0 0 0 n3 0 dio_pin_ft cpin=4.9999999999999997e-12 vihf=0.69999999999999996 vilf=0.29999999999999999
Xc1_PA7 n1 c1_PA7_din c1_PA7_und 0 0 0 n3 0 dio_pin_ft cpin=4.9999999999999997e-12 vihf=0.69999999999999996 vilf=0.29999999999999999
Xc1_PA8 n1 c1_PA8_din c1_PA8_und 0 0 0 n3 0 dio_pin_ft cpin=4.9999999999999997e-12 vihf=0.69999999999999996 vilf=0.29999999999999999
Xc1_PA9 n1 c1_PA9_din c1_PA9_und 0 0 0 n3 0 dio_pin_ft cpin=4.9999999999999997e-12 vihf=0.69999999999999996 vilf=0.29999999999999999
Xc1_PB0 n1 c1_PB0_din c1_PB0_und 0 0 0 n3 0 dio_pin_ft cpin=4.9999999999999997e-12 vihf=0.69999999999999996 vilf=0.29999999999999999
Xc1_PB1 n1 c1_PB1_din c1_PB1_und 0 0 0 n3 0 dio_pin_ft cpin=4.9999999999999997e-12 vihf=0.69999999999999996 vilf=0.29999999999999999
Xc1_PB10 n1 c1_PB10_din c1_PB10_und 0 0 0 n3 0 dio_pin_ft cpin=4.9999999999999997e-12 vihf=0.69999999999999996 vilf=0.29999999999999999
Xc1_PB11 n1 c1_PB11_din c1_PB11_und 0 0 0 n3 0 dio_pin_ft cpin=4.9999999999999997e-12 vihf=0.69999999999999996 vilf=0.29999999999999999
Xc1_PB12 n1 c1_PB12_din c1_PB12_und 0 0 0 n3 0 dio_pin_ft cpin=4.9999999999999997e-12 vihf=0.69999999999999996 vilf=0.29999999999999999
Xc1_PB13 n1 c1_PB13_din c1_PB13_und 0 0 0 n3 0 dio_pin_ft cpin=4.9999999999999997e-12 vihf=0.69999999999999996 vilf=0.29999999999999999
Xc1_PB14 n1 c1_PB14_din c1_PB14_und 0 0 0 n3 0 dio_pin_ft cpin=4.9999999999999997e-12 vihf=0.69999999999999996 vilf=0.29999999999999999
Xc1_PB15 n1 c1_PB15_din c1_PB15_und 0 0 0 n3 0 dio_pin_ft cpin=4.9999999999999997e-12 vihf=0.69999999999999996 vilf=0.29999999999999999
Xc1_PB2 n1 c1_PB2_din c1_PB2_und 0 0 0 n3 0 dio_pin_ft cpin=4.9999999999999997e-12 vihf=0.69999999999999996 vilf=0.29999999999999999
Xc1_PB5 n1 c1_PB5_din c1_PB5_und 0 0 0 n3 0 dio_pin_ft cpin=4.9999999999999997e-12 vihf=0.69999999999999996 vilf=0.29999999999999999
Xc1_PB6 n1 c1_PB6_din c1_PB6_und 0 0 0 n3 0 dio_pin_ft cpin=4.9999999999999997e-12 vihf=0.69999999999999996 vilf=0.29999999999999999
Xc1_PB7 n1 c1_PB7_din c1_PB7_und 0 0 0 n3 0 dio_pin_ft cpin=4.9999999999999997e-12 vihf=0.69999999999999996 vilf=0.29999999999999999
Xc1_PB8 n1 c1_PB8_din c1_PB8_und 0 0 0 n3 0 dio_pin_ft cpin=4.9999999999999997e-12 vihf=0.69999999999999996 vilf=0.29999999999999999
Xc1_PB9 n1 c1_PB9_din c1_PB9_und 0 0 0 n3 0 dio_pin_ft cpin=4.9999999999999997e-12 vihf=0.69999999999999996 vilf=0.29999999999999999
Xc1_PC0 n1 c1_PC0_din c1_PC0_und 0 0 0 n3 0 dio_pin_ft cpin=4.9999999999999997e-12 vihf=0.69999999999999996 vilf=0.29999999999999999
Xc1_PC1 n1 c1_PC1_din c1_PC1_und 0 0 0 n3 0 dio_pin_ft cpin=4.9999999999999997e-12 vihf=0.69999999999999996 vilf=0.29999999999999999
Xc1_PC10 n1 c1_PC10_din c1_PC10_und 0 0 0 n3 0 dio_pin_ft cpin=4.9999999999999997e-12 vihf=0.69999999999999996 vilf=0.29999999999999999
Xc1_PC11 n1 c1_PC11_din c1_PC11_und 0 0 0 n3 0 dio_pin_ft cpin=4.9999999999999997e-12 vihf=0.69999999999999996 vilf=0.29999999999999999
Xc1_PC12 n1 c1_PC12_din c1_PC12_und 0 0 0 n3 0 dio_pin_ft cpin=4.9999999999999997e-12 vihf=0.69999999999999996 vilf=0.29999999999999999
Xc1_PC2 n1 c1_PC2_din c1_PC2_und 0 0 0 n3 0 dio_pin_ft cpin=4.9999999999999997e-12 vihf=0.69999999999999996 vilf=0.29999999999999999
Xc1_PC3 n1 c1_PC3_din c1_PC3_und 0 0 0 n3 0 dio_pin_ft cpin=4.9999999999999997e-12 vihf=0.69999999999999996 vilf=0.29999999999999999
Xc1_PC4 n1 c1_PC4_din c1_PC4_und 0 0 0 n3 0 dio_pin_ft cpin=4.9999999999999997e-12 vihf=0.69999999999999996 vilf=0.29999999999999999
Xc1_PC5 n1 c1_PC5_din c1_PC5_und 0 0 0 n3 0 dio_pin_ft cpin=4.9999999999999997e-12 vihf=0.69999999999999996 vilf=0.29999999999999999
Xc1_PC6 n1 c1_PC6_din c1_PC6_und 0 0 0 n3 0 dio_pin_ft cpin=4.9999999999999997e-12 vihf=0.69999999999999996 vilf=0.29999999999999999
Xc1_PC7 n1 c1_PC7_din c1_PC7_und 0 0 0 n3 0 dio_pin_ft cpin=4.9999999999999997e-12 vihf=0.69999999999999996 vilf=0.29999999999999999
Xc1_PC8 n1 c1_PC8_din c1_PC8_und 0 0 0 n3 0 dio_pin_ft cpin=4.9999999999999997e-12 vihf=0.69999999999999996 vilf=0.29999999999999999
Xc1_PC9 n1 c1_PC9_din c1_PC9_und 0 0 0 n3 0 dio_pin_ft cpin=4.9999999999999997e-12 vihf=0.69999999999999996 vilf=0.29999999999999999
Xc1_PD2 n1 c1_PD2_din c1_PD2_und 0 0 0 n3 0 dio_pin_ft cpin=4.9999999999999997e-12 vihf=0.69999999999999996 vilf=0.29999999999999999
Xc1_PH0 n1 c1_PH0_din c1_PH0_und 0 0 0 n3 0 dio_pin_ft cpin=4.9999999999999997e-12 vihf=0.69999999999999996 vilf=0.29999999999999999
Xc1_PH1 n1 c1_PH1_din c1_PH1_und 0 0 0 n3 0 dio_pin_ft cpin=4.9999999999999997e-12 vihf=0.69999999999999996 vilf=0.29999999999999999
* BEH-IC-DIGITAL-IO: electrical interface of a digital pin of an MCU / serial EEPROM (L2 pad model; the firmware/protocol behaviour is L3 and NOT simulated).
* pad din dout oe vcc gnd : pad = package pin; dout/oe = normalised (0..1, as node voltages) data and output-enable from a higher layer; din = normalised receive level (0..1) + 'und' flag node
* Input: Cpin, leakage, ESD clamps to rails; decision regions VIL = vilf*Vcc, VIH = vihf*Vcc, 'und' = 1 between them (undefined input level -> simulator should flag).
* Output: push-pull Thevenin roh/rol, hi-Z with leakage when oe=0; optional pull-up (rpu) when pu=1 and oe=0.
.model dpad d(is=1e-14 n=1 rs=5)
.subckt dio_pin pad din und dout oe pu vcc gndport params: vilf=0.3 vihf=0.6 roh=40 rol=20 cpin=4p ileak=1u rpu=35k
Cp pad gndport {cpin}
Dh pad vcc dpad
Dl gndport pad dpad
Bleak pad gndport I=(1-v(oe))*{ileak}*tanh((v(pad)-v(gndport))/0.1)*0.0
Bin din gndport V=0.5*(1+tanh((v(pad)-(v(gndport)+0.5*({vilf}+{vihf})*(v(vcc)-v(gndport))))/(0.02*(v(vcc)-v(gndport)))))
Bun und gndport V=0.25*(1+tanh((v(pad)-(v(gndport)+{vilf}*(v(vcc)-v(gndport))))/0.05))*(1-tanh((v(pad)-(v(gndport)+{vihf}*(v(vcc)-v(gndport))))/0.05))
Bth pad gndport I=v(oe)*(v(pad)-(v(gndport)+v(dout)*(v(vcc)-v(gndport))))/({roh}*v(dout)+{rol}*(1-v(dout)))
Bsup vcc gndport I=v(oe)*max(((v(gndport)+v(dout)*(v(vcc)-v(gndport)))-v(pad))/({roh}*v(dout)+{rol}*(1-v(dout))),0)
Bpu vcc pad I=(1-v(oe))*v(pu)*(v(vcc)-v(pad))/{rpu}
.ends

* D075 variant of the BEH-IC-DIGITAL-IO pad (docs/behavior/bench/ic-digital-io/dio.lib, sha256 d4ce6b4f07531da603c125789fad97b8cb9115c47a81aa2555dddbb897168bba).
* Identical except that the upper clamp diode Dh (pad to vcc) is removed. Used only where the bound source states that the pin has
* no clamp to its supply: STM32 five-volt-tolerant (FT) pins ('Positive injection is not possible on these I/Os', DS8626 Rev 12
* Table 12 note 3; DS5319 Rev 20 Table 7 note 3), and the AVR RESET input rated to +13.0 V. Firmware and protocol are L3 and not simulated.
.model dpad d(is=1e-14 n=1 rs=5)
.subckt dio_pin_ft pad din und dout oe pu vcc gndport params: vilf=0.3 vihf=0.6 roh=40 rol=20 cpin=4p ileak=1u rpu=35k
Cp pad gndport {cpin}
Dl gndport pad dpad
Bleak pad gndport I=(1-v(oe))*{ileak}*tanh((v(pad)-v(gndport))/0.1)*0.0
Bin din gndport V=0.5*(1+tanh((v(pad)-(v(gndport)+0.5*({vilf}+{vihf})*(v(vcc)-v(gndport))))/(0.02*(v(vcc)-v(gndport)))))
Bun und gndport V=0.25*(1+tanh((v(pad)-(v(gndport)+{vilf}*(v(vcc)-v(gndport))))/0.05))*(1-tanh((v(pad)-(v(gndport)+{vihf}*(v(vcc)-v(gndport))))/0.05))
Bth pad gndport I=v(oe)*(v(pad)-(v(gndport)+v(dout)*(v(vcc)-v(gndport))))/({roh}*v(dout)+{rol}*(1-v(dout)))
Bsup vcc gndport I=v(oe)*max(((v(gndport)+v(dout)*(v(vcc)-v(gndport)))-v(pad))/({roh}*v(dout)+{rol}*(1-v(dout))),0)
Bpu vcc pad I=(1-v(oe))*v(pu)*(v(vcc)-v(pad))/{rpu}
.ends

.op
.print op
.end
