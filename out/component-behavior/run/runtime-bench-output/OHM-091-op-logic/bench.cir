OHMNI sourced behavior circuit
.options tnom=25
.temp 25
Vsource1 n1 0 DC 5
Vsource4 n4 0 DC 5
Bc1idd n4 0 I = 0.001
RV0c1 n2 0 100Meg
Rc1bl n1 0 38.46153846153846
.op
.print op
.end
