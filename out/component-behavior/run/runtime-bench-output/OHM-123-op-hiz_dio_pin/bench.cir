OHMNI sourced behavior circuit
.options tnom=25
.temp 25
Vsource2 n2 0 DC 0
Vsource3 n3 0 DC 5.5
Vc1_pu c1_pu 0 DC 1
Xc1_PB0 n2 c1_PB0_din c1_PB0_und 0 0 0 n3 0 dio_pin
Xc1_PB1 n1 c1_PB1_din c1_PB1_und 0 0 0 n3 0 dio_pin
Xc1_PB2 n1 c1_PB2_din c1_PB2_und 0 0 0 n3 0 dio_pin
Xc1_PB3 n1 c1_PB3_din c1_PB3_und 0 0 0 n3 0 dio_pin
Xc1_PB4 n1 c1_PB4_din c1_PB4_und 0 0 0 n3 0 dio_pin
Xc1_PB5 n1 c1_PB5_din c1_PB5_und 0 0 0 n3 0 dio_pin
Xc1_PB6 n1 c1_PB6_din c1_PB6_und 0 0 0 n3 0 dio_pin
Xc1_PB7 n1 c1_PB7_din c1_PB7_und 0 0 0 n3 0 dio_pin
Xc1_PC6 n1 c1_PC6_din c1_PC6_und 0 0 0 n3 0 dio_pin
Xc1_PC7 n1 c1_PC7_din c1_PC7_und 0 0 0 n3 0 dio_pin
Xc1_PD0 n1 c1_PD0_din c1_PD0_und 0 0 0 n3 0 dio_pin
Xc1_PD1 n1 c1_PD1_din c1_PD1_und 0 0 0 n3 0 dio_pin
Xc1_PD2 n1 c1_PD2_din c1_PD2_und 0 0 0 n3 0 dio_pin
Xc1_PD3 n1 c1_PD3_din c1_PD3_und 0 0 0 n3 0 dio_pin
Xc1_PD4 n1 c1_PD4_din c1_PD4_und 0 0 0 n3 0 dio_pin
Xc1_PD5 n1 c1_PD5_din c1_PD5_und 0 0 0 n3 0 dio_pin
Xc1_PD6 n1 c1_PD6_din c1_PD6_und 0 0 0 n3 0 dio_pin
Xc1_PD7 n1 c1_PD7_din c1_PD7_und 0 0 0 n3 0 dio_pin
Xc1_PE2 n1 c1_PE2_din c1_PE2_und 0 0 0 n3 0 dio_pin
Xc1_PE6 n1 c1_PE6_din c1_PE6_und 0 0 0 n3 0 dio_pin
Xc1_PF0 n1 c1_PF0_din c1_PF0_und 0 0 0 n3 0 dio_pin
Xc1_PF1 n1 c1_PF1_din c1_PF1_und 0 0 0 n3 0 dio_pin
Xc1_PF4 n1 c1_PF4_din c1_PF4_und 0 0 c1_pu n3 0 dio_pin rpu=35000
Xc1_PF5 n1 c1_PF5_din c1_PF5_und 0 0 c1_pu n3 0 dio_pin rpu=35000
Xc1_PF7 n1 c1_PF7_din c1_PF7_und 0 0 c1_pu n3 0 dio_pin rpu=35000
Xc1_RESET n1 c1_RESET_din c1_RESET_und 0 0 c1_pu n3 0 dio_pin_ft rpu=45000
* BEH-IC-DIGITAL-IO: electrical interface of a digital pin of an MCU / serial EEPROM (L2 pad model; the firmware/protocol behaviour is L3 and NOT simulated).
* pad din dout oe vcc gnd : pad = package pin; dout/oe = normalised (0..1, as node voltages) data and output-enable from a higher layer; din = normalised receive level (0..1) + 'und' flag node
* Input: Cpin, leakage, ESD clamps to rails; decision regions VIL = vilf*Vcc, VIH = vihf*Vcc, 'und' = 1 between them (undefined input level -> simulator should flag).
* Output: push-pull Thevenin roh/rol, hi-Z with leakage when oe=0; optional pull-up (rpu) when pu=1 and oe=0.
.model dpad d(is=1e-14 n=1 rs=5)
.subckt dio_pin pad din und dout oe pu vcc gndport params: vilf=0.3 vihf=0.6 roh=40 rol=20 cpin=4p ileak=1u rpu=35k
Cp pad gndport {cpin}
Dh pad vcc dpad
Dl gndport pad dpad
Bleak pad gndport I=(1-v(oe))*{ileak}*tanh((v(pad)-v(gndport))/0.1)*0.0
Bin din gndport V=0.5*(1+tanh((v(pad)-(v(gndport)+0.5*({vilf}+{vihf})*(v(vcc)-v(gndport))))/(0.02*(v(vcc)-v(gndport)))))
Bun und gndport V=0.25*(1+tanh((v(pad)-(v(gndport)+{vilf}*(v(vcc)-v(gndport))))/0.05))*(1-tanh((v(pad)-(v(gndport)+{vihf}*(v(vcc)-v(gndport))))/0.05))
Bth pad gndport I=v(oe)*(v(pad)-(v(gndport)+v(dout)*(v(vcc)-v(gndport))))/({roh}*v(dout)+{rol}*(1-v(dout)))
Bsup vcc gndport I=v(oe)*max(((v(gndport)+v(dout)*(v(vcc)-v(gndport)))-v(pad))/({roh}*v(dout)+{rol}*(1-v(dout))),0)
Bpu vcc pad I=(1-v(oe))*v(pu)*(v(vcc)-v(pad))/{rpu}
.ends

* D075 variant of the BEH-IC-DIGITAL-IO pad (docs/behavior/bench/ic-digital-io/dio.lib, sha256 d4ce6b4f07531da603c125789fad97b8cb9115c47a81aa2555dddbb897168bba).
* Identical except that the upper clamp diode Dh (pad to vcc) is removed. Used only where the bound source states that the pin has
* no clamp to its supply: STM32 five-volt-tolerant (FT) pins ('Positive injection is not possible on these I/Os', DS8626 Rev 12
* Table 12 note 3; DS5319 Rev 20 Table 7 note 3), and the AVR RESET input rated to +13.0 V. Firmware and protocol are L3 and not simulated.
.model dpad d(is=1e-14 n=1 rs=5)
.subckt dio_pin_ft pad din und dout oe pu vcc gndport params: vilf=0.3 vihf=0.6 roh=40 rol=20 cpin=4p ileak=1u rpu=35k
Cp pad gndport {cpin}
Dl gndport pad dpad
Bleak pad gndport I=(1-v(oe))*{ileak}*tanh((v(pad)-v(gndport))/0.1)*0.0
Bin din gndport V=0.5*(1+tanh((v(pad)-(v(gndport)+0.5*({vilf}+{vihf})*(v(vcc)-v(gndport))))/(0.02*(v(vcc)-v(gndport)))))
Bun und gndport V=0.25*(1+tanh((v(pad)-(v(gndport)+{vilf}*(v(vcc)-v(gndport))))/0.05))*(1-tanh((v(pad)-(v(gndport)+{vihf}*(v(vcc)-v(gndport))))/0.05))
Bth pad gndport I=v(oe)*(v(pad)-(v(gndport)+v(dout)*(v(vcc)-v(gndport))))/({roh}*v(dout)+{rol}*(1-v(dout)))
Bsup vcc gndport I=v(oe)*max(((v(gndport)+v(dout)*(v(vcc)-v(gndport)))-v(pad))/({roh}*v(dout)+{rol}*(1-v(dout))),0)
Bpu vcc pad I=(1-v(oe))*v(pu)*(v(vcc)-v(pad))/{rpu}
.ends

.op
.print op
.end
