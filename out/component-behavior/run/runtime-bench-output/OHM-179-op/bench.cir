OHMNI sourced behavior circuit
.options tnom=25
.temp 25
Iexcitation1 0 n1 DC 0.5
Rc1_c1 n1 0 0.10000000000000001
Rc1_c2 0 0 0.10000000000000001
Rc1_c3 0 0 0.10000000000000001
Rc1_c4 0 0 0.10000000000000001
Rc1_c5 0 0 0.10000000000000001
Rc1_c6 0 0 0.10000000000000001
Rc1_c7 0 0 0.10000000000000001
Rc1_c8 0 0 0.10000000000000001
Rc1_c9 0 0 0.10000000000000001
.op
.print op
.end
