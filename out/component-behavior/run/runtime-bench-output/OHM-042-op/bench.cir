OHMNI sourced behavior circuit
.options tnom=25
.temp 25
Iexcitation1 0 n2 DC 0.80000000000000004
Rc1 n2 0 0.39000000000000001
.op
.print op
.end
