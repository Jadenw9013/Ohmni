OHMNI sourced behavior circuit
.options tnom=25
.temp 25
Iexcitation1 0 n1 DC 0.014999999999999999
Rc1_P 0 0 44
Rc1_S n1 0 58
.op
.print op
.end
