OHMNI sourced behavior circuit
.options tnom=25
.temp 25
Iexcitation1 0 n1 DC 0.001
Rc1 n1 0 10000
.op
.print op
.end
