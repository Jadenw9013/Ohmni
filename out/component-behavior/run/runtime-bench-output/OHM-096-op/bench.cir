OHMNI sourced behavior circuit
.options tnom=25
.temp 25
Vsource2 n2 0 DC 2
Iexcitation1 0 n1 DC 0.0011952286093343937
Qc1 n2 n1 0 QMOD_c1
.model QMOD_c1 NPN(IS=7.3000000000000004e-14 BF=125.49900398011133)
.op
.print op
.end
