OHMNI sourced behavior circuit
.options tnom=25
.temp 25
Vsource6 n6 0 DC 4.5
Iexcitation1 n1 0 DC 0.0040000000000000001
Iexcitation2 n2 0 DC 0.0040000000000000001
Iexcitation3 n3 0 DC 0.0040000000000000001
Iexcitation4 n4 0 DC 0.0040000000000000001
Xc1_g1 0 0 n1 n6 0 hc_nand2 roh=50 rol=65 td=1.04e-08 taue=6.4000000000000002e-09 ci=3.0000000000000001e-12 cpd=1.9999999999999999e-11 icc0=1.9999999999999999e-06
Xc1_g2 0 0 n2 n6 0 hc_nand2 roh=50 rol=65 td=1.04e-08 taue=6.4000000000000002e-09 ci=3.0000000000000001e-12 cpd=1.9999999999999999e-11 icc0=1.9999999999999999e-06
Xc1_g3 0 0 n3 n6 0 hc_nand2 roh=50 rol=65 td=1.04e-08 taue=6.4000000000000002e-09 ci=3.0000000000000001e-12 cpd=1.9999999999999999e-11 icc0=1.9999999999999999e-06
Xc1_g4 0 0 n4 n6 0 hc_nand2 roh=50 rol=65 td=1.04e-08 taue=6.4000000000000002e-09 ci=3.0000000000000001e-12 cpd=1.9999999999999999e-11 icc0=1.9999999999999999e-06
* BEH-IC-LOGIC-HC L2 gate cells (behavioural_approximation). ngspice 42 stock (B sources, T line, D) - no XSPICE needed.
* Calibrated to TI SCLS181H (SN74HC00) / SCLS085L (SN74HC14) typical values at Vcc = 4.5 V, CL = 50 pF (see class text).
* Common pieces:
*  - input: Ci to gnd, ESD clamp diodes to vcc and gnd, decision at vtfrac*Vcc with 50 mV tanh smoothing
*  - core logic -> pure transport delay (lossless T line, matched) -> single-pole edge shaper -> Thevenin-style output (roh high, rol low)
*  - output: ONE Thevenin source (Vtarget = s*Vcc behind R = roh*s+rol*(1-s)); supply current taken = positive part of the sourced current (no crowbar), so Cpd is not double counted
*  - supply current: icc0 static + 0.5*Cpd*Vcc*|d(logic)/dt| (average = Cpd*Vcc*f)
.model dclamp d(is=1e-14 n=1 rs=5 cjo=0)
* ---------- 2-input NAND (74HC00 channel) ----------
.subckt hc_nand2 a b y vcc gndport params: vtfrac=0.5 roh=50 rol=65 td=10.4n taue=6.4n ci=5p cpd=20p icc0=2u
Cia a gndport {ci}
Cib b gndport {ci}
Dah a vcc dclamp
Dal gndport a dclamp
Dbh b vcc dclamp
Dbl gndport b dclamp
Bl lg gndport V=1-(0.5*(1+tanh((v(a)-(v(gndport)+vtfrac*(v(vcc)-v(gndport))))/0.05)))*(0.5*(1+tanh((v(b)-(v(gndport)+vtfrac*(v(vcc)-v(gndport))))/0.05)))
Rsd lg d2 50
T1 d2 gndport d3 gndport Z0=50 TD={td}
Rtd d3 gndport 50
Bsh sh gndport V=2*v(d3)
Rsh sh sh2 {taue/1p}
Csh sh2 gndport 1p
Bth y gndport I=(v(y)-(v(gndport)+min(max(v(sh2),0),1)*(v(vcc)-v(gndport))))/(roh*min(max(v(sh2),0),1)+rol*(1-min(max(v(sh2),0),1)))
Bsup vcc gndport I=max(((v(gndport)+min(max(v(sh2),0),1)*(v(vcc)-v(gndport)))-v(y))/(roh*min(max(v(sh2),0),1)+rol*(1-min(max(v(sh2),0),1))),0)
Dyh y vcc dclamp
Dyl gndport y dclamp
Bicc vcc gndport I={icc0}+0.5*cpd*(v(vcc)-v(gndport))*abs(ddt(v(sh2)))
.ends
* ---------- inverter (74HC04 channel) ----------
.subckt hc_inv a y vcc gndport params: vtfrac=0.5 roh=50 rol=65 td=10.4n taue=6.4n ci=5p cpd=20p icc0=2u
Cia a gndport {ci}
Dah a vcc dclamp
Dal gndport a dclamp
Bl lg gndport V=1-(0.5*(1+tanh((v(a)-(v(gndport)+vtfrac*(v(vcc)-v(gndport))))/0.05)))
Rsd lg d2 50
T1 d2 gndport d3 gndport Z0=50 TD={td}
Rtd d3 gndport 50
Bsh sh gndport V=2*v(d3)
Rsh sh sh2 {taue/1p}
Csh sh2 gndport 1p
Bth y gndport I=(v(y)-(v(gndport)+min(max(v(sh2),0),1)*(v(vcc)-v(gndport))))/(roh*min(max(v(sh2),0),1)+rol*(1-min(max(v(sh2),0),1)))
Bsup vcc gndport I=max(((v(gndport)+min(max(v(sh2),0),1)*(v(vcc)-v(gndport)))-v(y))/(roh*min(max(v(sh2),0),1)+rol*(1-min(max(v(sh2),0),1))),0)
Dyh y vcc dclamp
Dyl gndport y dclamp
Bicc vcc gndport I={icc0}+0.5*cpd*(v(vcc)-v(gndport))*abs(ddt(v(sh2)))
.ends
* ---------- Schmitt inverter (74HC14 channel): hysteresis latch, VT+ / VT- as fractions of Vcc (defaults = SCLS085L typ at 4.5 V: 2.5 V / 1.6 V) ----------
.subckt hc_inv_st a y vcc gndport params: vtp=0.5556 vtm=0.3556 roh=50 rol=65 td=10.4n taue=6.4n ci=5p cpd=20p icc0=2u klatch=1e9
Cia a gndport {ci}
Dah a vcc dclamp
Dal gndport a dclamp
* state q = 1 means output high; set when input below VT-, reset when input above VT+
Bs sset gndport V=0.5*(1+tanh(((v(gndport)+vtm*(v(vcc)-v(gndport)))-v(a))/0.002))
Br srst gndport V=0.5*(1+tanh((v(a)-(v(gndport)+vtp*(v(vcc)-v(gndport))))/0.002))
Cq q gndport 1 ic=0
Bq gndport q I={klatch}*(v(sset)*(1-v(srst))*(1-v(q)) - v(srst)*v(q))
Rq q gndport 1e12
Rsd q d2 50
T1 d2 gndport d3 gndport Z0=50 TD={td}
Rtd d3 gndport 50
Bsh sh gndport V=2*v(d3)
Rsh sh sh2 {taue/1p}
Csh sh2 gndport 1p
Bth y gndport I=(v(y)-(v(gndport)+min(max(v(sh2),0),1)*(v(vcc)-v(gndport))))/(roh*min(max(v(sh2),0),1)+rol*(1-min(max(v(sh2),0),1)))
Bsup vcc gndport I=max(((v(gndport)+min(max(v(sh2),0),1)*(v(vcc)-v(gndport)))-v(y))/(roh*min(max(v(sh2),0),1)+rol*(1-min(max(v(sh2),0),1))),0)
Dyh y vcc dclamp
Dyl gndport y dclamp
Bicc vcc gndport I={icc0}+0.5*cpd*(v(vcc)-v(gndport))*abs(ddt(v(sh2)))
.ends

.op
.print op
.end
