OHMNI sourced behavior circuit
.options tnom=25
.temp 25
Iexcitation1 0 n1 DC 1
Dc1 n1 0 DMOD_c1
.model DMOD_c1 D (IS=1.1829999999999999e-07 N=2.2629999999999999 RS=0.039390000000000001 CJO=3.1100000000000001e-11 VJ=0.69999999999999996 M=0.5 TT=4.4390000000000002e-06 BV=1100 IBV=5.0000000000000004e-06 EG=1.1100000000000001 XTI=3)
.op
.print op
.end
