OHMNI sourced behavior circuit
.options tnom=25
.temp 25
Iexcitation1 0 n1 DC 12
Rc1_mt1 n1 0 0.0014
Rc1_mt2 0 0 0.0014
.op
.print op
.end
