OHMNI sourced behavior circuit
.options tnom=25
.temp 25
Vsource4 n4 0 DC 3
Iexcitation1 n2 0 DC 0.10000000000000001
Xc1 n4 0 n4 n2 tlv700 vnom=3.2999999999999998 rdo=0.85999999999999999 rout=0.040000000000000001 icl=0.42999999999999999 rth=235.90000000000001 ta=25 iq=3.1000000000000001e-05 ven_hi=0.90000000000000002 ven_lo=0.40000000000000002
.nodeset v(n2)=2.9699999999999998
* BEH-IC-LDO-SOT235 behavioural LDO for the TLV700xx family (TLV70033 = 3.3 V). behavioural_approximation. ngspice 42 stock.
* pins: in gnd en out   (SOT-23-5 DDC order is IN=1 GND=2 EN=3 NC=4 OUT=5; the package binding maps these)
* Pass element = current source I = icl*tanh(Iraw/icl)*enable*(1-shutdown), Iraw = a*b/(a+b) with a=(Vreg-Vout)/rout (regulation branch) and b=(Vin-Vout)/rdo (dropout branch): soft knee, output impedance ~rout, dropout resistance ~rdo, current limit icl, cannot sink current. (Smooth form chosen because hard min() kinks made ngspice's op solve fail.)
* Thermal: Pd -> Rth_ja -> Ta; memoryless thermal limiter: output current scaled by (1 - 0.5*(1+tanh((Tj-tsd_hi)/2))). The real part has hysteresis (~160 C off, ~140 C on, TI SLVSA00E extract) - NOT modelled (a latch has no unique DC solution); the model regulates at ~tsd_hi (time-average of the real thermal cycling). cth is an ASSUMPTION.
.subckt tlv700 in gndport en out params: vnom=3.3 acc=0 rdo=0.86 rout=0.04 icl=0.43 iq=31u ign200=270u ven_hi=0.9 ven_lo=0.4 rth=235.9 ta=25 tsd_hi=160 cth=0.05
* enable (hysteretic latch not modelled; single threshold at the mean of ven_hi/ven_lo)
Ben enb gndport V=0.5*(1+tanh((v(en)-v(gndport)-0.5*({ven_hi}+{ven_lo}))/0.02))
* thermal network: temperature in volts (1 V = 1 degC)
Vta tamb gndport dc {ta}
Rth tj tamb {rth}
Cth tj tamb {cth} ic=0
Bpd gndport tj I=max((v(in)-v(out))*v(ip)+v(in)*v(enb)*(iq+(ign200-iq)*min(max(v(ip)/0.2,0),1)),0)
Bts ts gndport V=0.5*(1+tanh((v(tj)-{tsd_hi})/2))
* pass element
Bip ip gndport V=v(enb)*(1-v(ts))*{icl}*tanh( ( ((0.5*(({vnom}*(1+acc)-(v(out)-v(gndport)))+sqrt(({vnom}*(1+acc)-(v(out)-v(gndport)))*({vnom}*(1+acc)-(v(out)-v(gndport)))+1e-8)))/{rout}+1e-9)*((0.5*((v(in)-v(out))+sqrt((v(in)-v(out))*(v(in)-v(out))+1e-8)))/{rdo}+1e-9) / (((0.5*(({vnom}*(1+acc)-(v(out)-v(gndport)))+sqrt(({vnom}*(1+acc)-(v(out)-v(gndport)))*({vnom}*(1+acc)-(v(out)-v(gndport)))+1e-8)))/{rout}+1e-9)+((0.5*((v(in)-v(out))+sqrt((v(in)-v(out))*(v(in)-v(out))+1e-8)))/{rdo}+1e-9)) )/{icl} )
Rip ip gndport 1e9
Bpass in out I=v(ip)
* internal feedback divider load (ASSUMED 1 Mohm, ~3 uA): also gives the output node a conductance to ground
Rfb out gndport 1Meg
* ground / quiescent current
Biq in gndport I=v(enb)*(iq+(ign200-iq)*min(max(v(ip)/0.2,0),1))
.ends

.op
.print op
.end
