OHMNI sourced behavior circuit
.options tnom=25
.temp 25
Iexcitation1 0 n1 DC 1
Rc1_m1 n1 0 0.02
Rc1_m2 0 0 0.02
Rc1_m3 0 0 0.02
Rc1_m4 0 0 0.02
.op
.print op
.end
