OHMNI sourced behavior circuit
.options tnom=25
.temp 25
Iexcitation1 0 n1 DC 5.0000000000000001e-09
Cc1 n1 0 4.7000000000000004e-08
Rc1_lk n1 0 10000000000
.op
.print op
.end
