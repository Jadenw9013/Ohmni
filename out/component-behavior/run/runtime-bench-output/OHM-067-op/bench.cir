OHMNI sourced behavior circuit
.options tnom=25
.temp 25
Iexcitation1 0 n1 DC 0.01
Dc1 n1 0 DBAT_c1
.model DBAT_c1 D (IS=6.8890000000000003e-08 N=1.077 RS=1.948 CJO=7.9999999999999998e-12 BV=30)
.op
.print op
.end
