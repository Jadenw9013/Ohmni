OHMNI sourced behavior circuit
.options tnom=25
.temp 25
Vsource3 n3 0 DC 5
Rc1 n3 n1 10000
Rc2 n1 0 10000
.op
.print op
.end
