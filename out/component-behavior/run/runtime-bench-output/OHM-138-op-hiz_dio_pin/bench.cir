OHMNI sourced behavior circuit
.options tnom=25
.temp 25
Vsource2 n2 0 DC 0
Vsource3 n3 0 DC 1.8899999999999999
Vsource4 n4 0 DC 1.05
Vsource5 n5 0 DC 1.05
Vsource6 n6 0 DC 3.4649999999999999
Vsource7 n7 0 DC 3.4649999999999999
Vsource8 n8 0 DC 3.4649999999999999
Vsource9 n9 0 DC 3.4649999999999999
Vsource10 n10 0 DC 3.4649999999999999
Xc1_IO_0_14 n2 c1_IO_0_14_din c1_IO_0_14_und 0 0 0 n7 0 dio_pin cpin=7.9999999999999998e-12
Xc1_IO_0_15 n1 c1_IO_0_15_din c1_IO_0_15_und 0 0 0 n8 0 dio_pin cpin=7.9999999999999998e-12
Xc1_IO_0_34 n1 c1_IO_0_34_din c1_IO_0_34_und 0 0 0 n9 0 dio_pin cpin=7.9999999999999998e-12
Xc1_IO_0_35 n1 c1_IO_0_35_din c1_IO_0_35_und 0 0 0 n10 0 dio_pin cpin=7.9999999999999998e-12
Xc1_IO_25_14 n1 c1_IO_25_14_din c1_IO_25_14_und 0 0 0 n7 0 dio_pin cpin=7.9999999999999998e-12
Xc1_IO_25_15 n1 c1_IO_25_15_din c1_IO_25_15_und 0 0 0 n8 0 dio_pin cpin=7.9999999999999998e-12
Xc1_IO_25_35 n1 c1_IO_25_35_din c1_IO_25_35_und 0 0 0 n10 0 dio_pin cpin=7.9999999999999998e-12
Xc1_IO_L10N_T1_AD11N_15 n1 c1_IO_L10N_T1_AD11N_15_din c1_IO_L10N_T1_AD11N_15_und 0 0 0 n8 0 dio_pin cpin=7.9999999999999998e-12
Xc1_IO_L10N_T1_AD15N_35 n1 c1_IO_L10N_T1_AD15N_35_din c1_IO_L10N_T1_AD15N_35_und 0 0 0 n10 0 dio_pin cpin=7.9999999999999998e-12
Xc1_IO_L10N_T1_D15_14 n1 c1_IO_L10N_T1_D15_14_din c1_IO_L10N_T1_D15_14_und 0 0 0 n7 0 dio_pin cpin=7.9999999999999998e-12
Xc1_IO_L10P_T1_34 n1 c1_IO_L10P_T1_34_din c1_IO_L10P_T1_34_und 0 0 0 n9 0 dio_pin cpin=7.9999999999999998e-12
Xc1_IO_L10P_T1_AD11P_15 n1 c1_IO_L10P_T1_AD11P_15_din c1_IO_L10P_T1_AD11P_15_und 0 0 0 n8 0 dio_pin cpin=7.9999999999999998e-12
Xc1_IO_L10P_T1_AD15P_35 n1 c1_IO_L10P_T1_AD15P_35_din c1_IO_L10P_T1_AD15P_35_und 0 0 0 n10 0 dio_pin cpin=7.9999999999999998e-12
Xc1_IO_L10P_T1_D14_14 n1 c1_IO_L10P_T1_D14_14_din c1_IO_L10P_T1_D14_14_und 0 0 0 n7 0 dio_pin cpin=7.9999999999999998e-12
Xc1_IO_L11N_T1_SRCC_14 n1 c1_IO_L11N_T1_SRCC_14_din c1_IO_L11N_T1_SRCC_14_und 0 0 0 n7 0 dio_pin cpin=7.9999999999999998e-12
Xc1_IO_L11N_T1_SRCC_15 n1 c1_IO_L11N_T1_SRCC_15_din c1_IO_L11N_T1_SRCC_15_und 0 0 0 n8 0 dio_pin cpin=7.9999999999999998e-12
Xc1_IO_L11N_T1_SRCC_35 n1 c1_IO_L11N_T1_SRCC_35_din c1_IO_L11N_T1_SRCC_35_und 0 0 0 n10 0 dio_pin cpin=7.9999999999999998e-12
Xc1_IO_L11P_T1_SRCC_14 n1 c1_IO_L11P_T1_SRCC_14_din c1_IO_L11P_T1_SRCC_14_und 0 0 0 n7 0 dio_pin cpin=7.9999999999999998e-12
Xc1_IO_L11P_T1_SRCC_15 n1 c1_IO_L11P_T1_SRCC_15_din c1_IO_L11P_T1_SRCC_15_und 0 0 0 n8 0 dio_pin cpin=7.9999999999999998e-12
Xc1_IO_L11P_T1_SRCC_35 n1 c1_IO_L11P_T1_SRCC_35_din c1_IO_L11P_T1_SRCC_35_und 0 0 0 n10 0 dio_pin cpin=7.9999999999999998e-12
Xc1_IO_L12N_T1_MRCC_14 n1 c1_IO_L12N_T1_MRCC_14_din c1_IO_L12N_T1_MRCC_14_und 0 0 0 n7 0 dio_pin cpin=7.9999999999999998e-12
Xc1_IO_L12N_T1_MRCC_15 n1 c1_IO_L12N_T1_MRCC_15_din c1_IO_L12N_T1_MRCC_15_und 0 0 0 n8 0 dio_pin cpin=7.9999999999999998e-12
Xc1_IO_L12N_T1_MRCC_35 n1 c1_IO_L12N_T1_MRCC_35_din c1_IO_L12N_T1_MRCC_35_und 0 0 0 n10 0 dio_pin cpin=7.9999999999999998e-12
Xc1_IO_L12P_T1_MRCC_14 n1 c1_IO_L12P_T1_MRCC_14_din c1_IO_L12P_T1_MRCC_14_und 0 0 0 n7 0 dio_pin cpin=7.9999999999999998e-12
Xc1_IO_L12P_T1_MRCC_15 n1 c1_IO_L12P_T1_MRCC_15_din c1_IO_L12P_T1_MRCC_15_und 0 0 0 n8 0 dio_pin cpin=7.9999999999999998e-12
Xc1_IO_L12P_T1_MRCC_35 n1 c1_IO_L12P_T1_MRCC_35_din c1_IO_L12P_T1_MRCC_35_und 0 0 0 n10 0 dio_pin cpin=7.9999999999999998e-12
Xc1_IO_L13N_T2_MRCC_14 n1 c1_IO_L13N_T2_MRCC_14_din c1_IO_L13N_T2_MRCC_14_und 0 0 0 n7 0 dio_pin cpin=7.9999999999999998e-12
Xc1_IO_L13N_T2_MRCC_15 n1 c1_IO_L13N_T2_MRCC_15_din c1_IO_L13N_T2_MRCC_15_und 0 0 0 n8 0 dio_pin cpin=7.9999999999999998e-12
Xc1_IO_L13N_T2_MRCC_35 n1 c1_IO_L13N_T2_MRCC_35_din c1_IO_L13N_T2_MRCC_35_und 0 0 0 n10 0 dio_pin cpin=7.9999999999999998e-12
Xc1_IO_L13P_T2_MRCC_14 n1 c1_IO_L13P_T2_MRCC_14_din c1_IO_L13P_T2_MRCC_14_und 0 0 0 n7 0 dio_pin cpin=7.9999999999999998e-12
Xc1_IO_L13P_T2_MRCC_15 n1 c1_IO_L13P_T2_MRCC_15_din c1_IO_L13P_T2_MRCC_15_und 0 0 0 n8 0 dio_pin cpin=7.9999999999999998e-12
Xc1_IO_L13P_T2_MRCC_35 n1 c1_IO_L13P_T2_MRCC_35_din c1_IO_L13P_T2_MRCC_35_und 0 0 0 n10 0 dio_pin cpin=7.9999999999999998e-12
Xc1_IO_L14N_T2_SRCC_14 n1 c1_IO_L14N_T2_SRCC_14_din c1_IO_L14N_T2_SRCC_14_und 0 0 0 n7 0 dio_pin cpin=7.9999999999999998e-12
Xc1_IO_L14N_T2_SRCC_15 n1 c1_IO_L14N_T2_SRCC_15_din c1_IO_L14N_T2_SRCC_15_und 0 0 0 n8 0 dio_pin cpin=7.9999999999999998e-12
Xc1_IO_L14N_T2_SRCC_35 n1 c1_IO_L14N_T2_SRCC_35_din c1_IO_L14N_T2_SRCC_35_und 0 0 0 n10 0 dio_pin cpin=7.9999999999999998e-12
Xc1_IO_L14P_T2_SRCC_14 n1 c1_IO_L14P_T2_SRCC_14_din c1_IO_L14P_T2_SRCC_14_und 0 0 0 n7 0 dio_pin cpin=7.9999999999999998e-12
Xc1_IO_L14P_T2_SRCC_15 n1 c1_IO_L14P_T2_SRCC_15_din c1_IO_L14P_T2_SRCC_15_und 0 0 0 n8 0 dio_pin cpin=7.9999999999999998e-12
Xc1_IO_L14P_T2_SRCC_35 n1 c1_IO_L14P_T2_SRCC_35_din c1_IO_L14P_T2_SRCC_35_und 0 0 0 n10 0 dio_pin cpin=7.9999999999999998e-12
Xc1_IO_L15N_T2_DQS_35 n1 c1_IO_L15N_T2_DQS_35_din c1_IO_L15N_T2_DQS_35_und 0 0 0 n10 0 dio_pin cpin=7.9999999999999998e-12
Xc1_IO_L15N_T2_DQS_ADV_B_15 n1 c1_IO_L15N_T2_DQS_ADV_B_15_din c1_IO_L15N_T2_DQS_ADV_B_15_und 0 0 0 n8 0 dio_pin cpin=7.9999999999999998e-12
Xc1_IO_L15N_T2_DQS_DOUT_CSO_B_14 n1 c1_IO_L15N_T2_DQS_DOUT_CSO_B_14_din c1_IO_L15N_T2_DQS_DOUT_CSO_B_14_und 0 0 0 n7 0 dio_pin cpin=7.9999999999999998e-12
Xc1_IO_L15P_T2_DQS_15 n1 c1_IO_L15P_T2_DQS_15_din c1_IO_L15P_T2_DQS_15_und 0 0 0 n8 0 dio_pin cpin=7.9999999999999998e-12
Xc1_IO_L15P_T2_DQS_35 n1 c1_IO_L15P_T2_DQS_35_din c1_IO_L15P_T2_DQS_35_und 0 0 0 n10 0 dio_pin cpin=7.9999999999999998e-12
Xc1_IO_L15P_T2_DQS_RDWR_B_14 n1 c1_IO_L15P_T2_DQS_RDWR_B_14_din c1_IO_L15P_T2_DQS_RDWR_B_14_und 0 0 0 n7 0 dio_pin cpin=7.9999999999999998e-12
Xc1_IO_L16N_T2_35 n1 c1_IO_L16N_T2_35_din c1_IO_L16N_T2_35_und 0 0 0 n10 0 dio_pin cpin=7.9999999999999998e-12
Xc1_IO_L16N_T2_A15_D31_14 n1 c1_IO_L16N_T2_A15_D31_14_din c1_IO_L16N_T2_A15_D31_14_und 0 0 0 n7 0 dio_pin cpin=7.9999999999999998e-12
Xc1_IO_L16N_T2_A27_15 n1 c1_IO_L16N_T2_A27_15_din c1_IO_L16N_T2_A27_15_und 0 0 0 n8 0 dio_pin cpin=7.9999999999999998e-12
Xc1_IO_L16P_T2_35 n1 c1_IO_L16P_T2_35_din c1_IO_L16P_T2_35_und 0 0 0 n10 0 dio_pin cpin=7.9999999999999998e-12
Xc1_IO_L16P_T2_A28_15 n1 c1_IO_L16P_T2_A28_15_din c1_IO_L16P_T2_A28_15_und 0 0 0 n8 0 dio_pin cpin=7.9999999999999998e-12
Xc1_IO_L16P_T2_CSI_B_14 n1 c1_IO_L16P_T2_CSI_B_14_din c1_IO_L16P_T2_CSI_B_14_und 0 0 0 n7 0 dio_pin cpin=7.9999999999999998e-12
Xc1_IO_L17N_T2_35 n1 c1_IO_L17N_T2_35_din c1_IO_L17N_T2_35_und 0 0 0 n10 0 dio_pin cpin=7.9999999999999998e-12
Xc1_IO_L17N_T2_A13_D29_14 n1 c1_IO_L17N_T2_A13_D29_14_din c1_IO_L17N_T2_A13_D29_14_und 0 0 0 n7 0 dio_pin cpin=7.9999999999999998e-12
Xc1_IO_L17N_T2_A25_15 n1 c1_IO_L17N_T2_A25_15_din c1_IO_L17N_T2_A25_15_und 0 0 0 n8 0 dio_pin cpin=7.9999999999999998e-12
Xc1_IO_L17P_T2_35 n1 c1_IO_L17P_T2_35_din c1_IO_L17P_T2_35_und 0 0 0 n10 0 dio_pin cpin=7.9999999999999998e-12
Xc1_IO_L17P_T2_A14_D30_14 n1 c1_IO_L17P_T2_A14_D30_14_din c1_IO_L17P_T2_A14_D30_14_und 0 0 0 n7 0 dio_pin cpin=7.9999999999999998e-12
Xc1_IO_L17P_T2_A26_15 n1 c1_IO_L17P_T2_A26_15_din c1_IO_L17P_T2_A26_15_und 0 0 0 n8 0 dio_pin cpin=7.9999999999999998e-12
Xc1_IO_L18N_T2_35 n1 c1_IO_L18N_T2_35_din c1_IO_L18N_T2_35_und 0 0 0 n10 0 dio_pin cpin=7.9999999999999998e-12
Xc1_IO_L18N_T2_A11_D27_14 n1 c1_IO_L18N_T2_A11_D27_14_din c1_IO_L18N_T2_A11_D27_14_und 0 0 0 n7 0 dio_pin cpin=7.9999999999999998e-12
Xc1_IO_L18N_T2_A23_15 n1 c1_IO_L18N_T2_A23_15_din c1_IO_L18N_T2_A23_15_und 0 0 0 n8 0 dio_pin cpin=7.9999999999999998e-12
Xc1_IO_L18P_T2_35 n1 c1_IO_L18P_T2_35_din c1_IO_L18P_T2_35_und 0 0 0 n10 0 dio_pin cpin=7.9999999999999998e-12
Xc1_IO_L18P_T2_A12_D28_14 n1 c1_IO_L18P_T2_A12_D28_14_din c1_IO_L18P_T2_A12_D28_14_und 0 0 0 n7 0 dio_pin cpin=7.9999999999999998e-12
Xc1_IO_L18P_T2_A24_15 n1 c1_IO_L18P_T2_A24_15_din c1_IO_L18P_T2_A24_15_und 0 0 0 n8 0 dio_pin cpin=7.9999999999999998e-12
Xc1_IO_L19N_T3_A09_D25_VREF_14 n1 c1_IO_L19N_T3_A09_D25_VREF_14_din c1_IO_L19N_T3_A09_D25_VREF_14_und 0 0 0 n7 0 dio_pin cpin=7.9999999999999998e-12
Xc1_IO_L19N_T3_A21_VREF_15 n1 c1_IO_L19N_T3_A21_VREF_15_din c1_IO_L19N_T3_A21_VREF_15_und 0 0 0 n8 0 dio_pin cpin=7.9999999999999998e-12
Xc1_IO_L19N_T3_VREF_35 n1 c1_IO_L19N_T3_VREF_35_din c1_IO_L19N_T3_VREF_35_und 0 0 0 n10 0 dio_pin cpin=7.9999999999999998e-12
Xc1_IO_L19P_T3_35 n1 c1_IO_L19P_T3_35_din c1_IO_L19P_T3_35_und 0 0 0 n10 0 dio_pin cpin=7.9999999999999998e-12
Xc1_IO_L19P_T3_A10_D26_14 n1 c1_IO_L19P_T3_A10_D26_14_din c1_IO_L19P_T3_A10_D26_14_und 0 0 0 n7 0 dio_pin cpin=7.9999999999999998e-12
Xc1_IO_L19P_T3_A22_15 n1 c1_IO_L19P_T3_A22_15_din c1_IO_L19P_T3_A22_15_und 0 0 0 n8 0 dio_pin cpin=7.9999999999999998e-12
Xc1_IO_L1N_T0_34 n1 c1_IO_L1N_T0_34_din c1_IO_L1N_T0_34_und 0 0 0 n9 0 dio_pin cpin=7.9999999999999998e-12
Xc1_IO_L1N_T0_AD0N_15 n1 c1_IO_L1N_T0_AD0N_15_din c1_IO_L1N_T0_AD0N_15_und 0 0 0 n8 0 dio_pin cpin=7.9999999999999998e-12
Xc1_IO_L1N_T0_AD4N_35 n1 c1_IO_L1N_T0_AD4N_35_din c1_IO_L1N_T0_AD4N_35_und 0 0 0 n10 0 dio_pin cpin=7.9999999999999998e-12
Xc1_IO_L1N_T0_D01_DIN_14 n1 c1_IO_L1N_T0_D01_DIN_14_din c1_IO_L1N_T0_D01_DIN_14_und 0 0 0 n7 0 dio_pin cpin=7.9999999999999998e-12
Xc1_IO_L1P_T0_34 n1 c1_IO_L1P_T0_34_din c1_IO_L1P_T0_34_und 0 0 0 n9 0 dio_pin cpin=7.9999999999999998e-12
Xc1_IO_L1P_T0_AD0P_15 n1 c1_IO_L1P_T0_AD0P_15_din c1_IO_L1P_T0_AD0P_15_und 0 0 0 n8 0 dio_pin cpin=7.9999999999999998e-12
Xc1_IO_L1P_T0_AD4P_35 n1 c1_IO_L1P_T0_AD4P_35_din c1_IO_L1P_T0_AD4P_35_und 0 0 0 n10 0 dio_pin cpin=7.9999999999999998e-12
Xc1_IO_L1P_T0_D00_MOSI_14 n1 c1_IO_L1P_T0_D00_MOSI_14_din c1_IO_L1P_T0_D00_MOSI_14_und 0 0 0 n7 0 dio_pin cpin=7.9999999999999998e-12
Xc1_IO_L20N_T3_35 n1 c1_IO_L20N_T3_35_din c1_IO_L20N_T3_35_und 0 0 0 n10 0 dio_pin cpin=7.9999999999999998e-12
Xc1_IO_L20N_T3_A07_D23_14 n1 c1_IO_L20N_T3_A07_D23_14_din c1_IO_L20N_T3_A07_D23_14_und 0 0 0 n7 0 dio_pin cpin=7.9999999999999998e-12
Xc1_IO_L20N_T3_A19_15 n1 c1_IO_L20N_T3_A19_15_din c1_IO_L20N_T3_A19_15_und 0 0 0 n8 0 dio_pin cpin=7.9999999999999998e-12
Xc1_IO_L20P_T3_35 n1 c1_IO_L20P_T3_35_din c1_IO_L20P_T3_35_und 0 0 0 n10 0 dio_pin cpin=7.9999999999999998e-12
Xc1_IO_L20P_T3_A08_D24_14 n1 c1_IO_L20P_T3_A08_D24_14_din c1_IO_L20P_T3_A08_D24_14_und 0 0 0 n7 0 dio_pin cpin=7.9999999999999998e-12
Xc1_IO_L20P_T3_A20_15 n1 c1_IO_L20P_T3_A20_15_din c1_IO_L20P_T3_A20_15_und 0 0 0 n8 0 dio_pin cpin=7.9999999999999998e-12
Xc1_IO_L21N_T3_DQS_35 n1 c1_IO_L21N_T3_DQS_35_din c1_IO_L21N_T3_DQS_35_und 0 0 0 n10 0 dio_pin cpin=7.9999999999999998e-12
Xc1_IO_L21N_T3_DQS_A06_D22_14 n1 c1_IO_L21N_T3_DQS_A06_D22_14_din c1_IO_L21N_T3_DQS_A06_D22_14_und 0 0 0 n7 0 dio_pin cpin=7.9999999999999998e-12
Xc1_IO_L21N_T3_DQS_A18_15 n1 c1_IO_L21N_T3_DQS_A18_15_din c1_IO_L21N_T3_DQS_A18_15_und 0 0 0 n8 0 dio_pin cpin=7.9999999999999998e-12
Xc1_IO_L21P_T3_DQS_14 n1 c1_IO_L21P_T3_DQS_14_din c1_IO_L21P_T3_DQS_14_und 0 0 0 n7 0 dio_pin cpin=7.9999999999999998e-12
Xc1_IO_L21P_T3_DQS_15 n1 c1_IO_L21P_T3_DQS_15_din c1_IO_L21P_T3_DQS_15_und 0 0 0 n8 0 dio_pin cpin=7.9999999999999998e-12
Xc1_IO_L21P_T3_DQS_35 n1 c1_IO_L21P_T3_DQS_35_din c1_IO_L21P_T3_DQS_35_und 0 0 0 n10 0 dio_pin cpin=7.9999999999999998e-12
Xc1_IO_L22N_T3_35 n1 c1_IO_L22N_T3_35_din c1_IO_L22N_T3_35_und 0 0 0 n10 0 dio_pin cpin=7.9999999999999998e-12
Xc1_IO_L22N_T3_A04_D20_14 n1 c1_IO_L22N_T3_A04_D20_14_din c1_IO_L22N_T3_A04_D20_14_und 0 0 0 n7 0 dio_pin cpin=7.9999999999999998e-12
Xc1_IO_L22N_T3_A16_15 n1 c1_IO_L22N_T3_A16_15_din c1_IO_L22N_T3_A16_15_und 0 0 0 n8 0 dio_pin cpin=7.9999999999999998e-12
Xc1_IO_L22P_T3_35 n1 c1_IO_L22P_T3_35_din c1_IO_L22P_T3_35_und 0 0 0 n10 0 dio_pin cpin=7.9999999999999998e-12
Xc1_IO_L22P_T3_A05_D21_14 n1 c1_IO_L22P_T3_A05_D21_14_din c1_IO_L22P_T3_A05_D21_14_und 0 0 0 n7 0 dio_pin cpin=7.9999999999999998e-12
Xc1_IO_L22P_T3_A17_15 n1 c1_IO_L22P_T3_A17_15_din c1_IO_L22P_T3_A17_15_und 0 0 0 n8 0 dio_pin cpin=7.9999999999999998e-12
Xc1_IO_L23N_T3_35 n1 c1_IO_L23N_T3_35_din c1_IO_L23N_T3_35_und 0 0 0 n10 0 dio_pin cpin=7.9999999999999998e-12
Xc1_IO_L23N_T3_A02_D18_14 n1 c1_IO_L23N_T3_A02_D18_14_din c1_IO_L23N_T3_A02_D18_14_und 0 0 0 n7 0 dio_pin cpin=7.9999999999999998e-12
Xc1_IO_L23N_T3_FWE_B_15 n1 c1_IO_L23N_T3_FWE_B_15_din c1_IO_L23N_T3_FWE_B_15_und 0 0 0 n8 0 dio_pin cpin=7.9999999999999998e-12
Xc1_IO_L23P_T3_35 n1 c1_IO_L23P_T3_35_din c1_IO_L23P_T3_35_und 0 0 0 n10 0 dio_pin cpin=7.9999999999999998e-12
Xc1_IO_L23P_T3_A03_D19_14 n1 c1_IO_L23P_T3_A03_D19_14_din c1_IO_L23P_T3_A03_D19_14_und 0 0 0 n7 0 dio_pin cpin=7.9999999999999998e-12
Xc1_IO_L23P_T3_FOE_B_15 n1 c1_IO_L23P_T3_FOE_B_15_din c1_IO_L23P_T3_FOE_B_15_und 0 0 0 n8 0 dio_pin cpin=7.9999999999999998e-12
Xc1_IO_L24N_T3_35 n1 c1_IO_L24N_T3_35_din c1_IO_L24N_T3_35_und 0 0 0 n10 0 dio_pin cpin=7.9999999999999998e-12
Xc1_IO_L24N_T3_A00_D16_14 n1 c1_IO_L24N_T3_A00_D16_14_din c1_IO_L24N_T3_A00_D16_14_und 0 0 0 n7 0 dio_pin cpin=7.9999999999999998e-12
Xc1_IO_L24N_T3_RS0_15 n1 c1_IO_L24N_T3_RS0_15_din c1_IO_L24N_T3_RS0_15_und 0 0 0 n8 0 dio_pin cpin=7.9999999999999998e-12
Xc1_IO_L24P_T3_35 n1 c1_IO_L24P_T3_35_din c1_IO_L24P_T3_35_und 0 0 0 n10 0 dio_pin cpin=7.9999999999999998e-12
Xc1_IO_L24P_T3_A01_D17_14 n1 c1_IO_L24P_T3_A01_D17_14_din c1_IO_L24P_T3_A01_D17_14_und 0 0 0 n7 0 dio_pin cpin=7.9999999999999998e-12
Xc1_IO_L24P_T3_RS1_15 n1 c1_IO_L24P_T3_RS1_15_din c1_IO_L24P_T3_RS1_15_und 0 0 0 n8 0 dio_pin cpin=7.9999999999999998e-12
Xc1_IO_L2N_T0_34 n1 c1_IO_L2N_T0_34_din c1_IO_L2N_T0_34_und 0 0 0 n9 0 dio_pin cpin=7.9999999999999998e-12
Xc1_IO_L2N_T0_AD12N_35 n1 c1_IO_L2N_T0_AD12N_35_din c1_IO_L2N_T0_AD12N_35_und 0 0 0 n10 0 dio_pin cpin=7.9999999999999998e-12
Xc1_IO_L2N_T0_AD8N_15 n1 c1_IO_L2N_T0_AD8N_15_din c1_IO_L2N_T0_AD8N_15_und 0 0 0 n8 0 dio_pin cpin=7.9999999999999998e-12
Xc1_IO_L2N_T0_D03_14 n1 c1_IO_L2N_T0_D03_14_din c1_IO_L2N_T0_D03_14_und 0 0 0 n7 0 dio_pin cpin=7.9999999999999998e-12
Xc1_IO_L2P_T0_34 n1 c1_IO_L2P_T0_34_din c1_IO_L2P_T0_34_und 0 0 0 n9 0 dio_pin cpin=7.9999999999999998e-12
Xc1_IO_L2P_T0_AD12P_35 n1 c1_IO_L2P_T0_AD12P_35_din c1_IO_L2P_T0_AD12P_35_und 0 0 0 n10 0 dio_pin cpin=7.9999999999999998e-12
Xc1_IO_L2P_T0_AD8P_15 n1 c1_IO_L2P_T0_AD8P_15_din c1_IO_L2P_T0_AD8P_15_und 0 0 0 n8 0 dio_pin cpin=7.9999999999999998e-12
Xc1_IO_L2P_T0_D02_14 n1 c1_IO_L2P_T0_D02_14_din c1_IO_L2P_T0_D02_14_und 0 0 0 n7 0 dio_pin cpin=7.9999999999999998e-12
Xc1_IO_L3N_T0_DQS_34 n1 c1_IO_L3N_T0_DQS_34_din c1_IO_L3N_T0_DQS_34_und 0 0 0 n9 0 dio_pin cpin=7.9999999999999998e-12
Xc1_IO_L3N_T0_DQS_AD1N_15 n1 c1_IO_L3N_T0_DQS_AD1N_15_din c1_IO_L3N_T0_DQS_AD1N_15_und 0 0 0 n8 0 dio_pin cpin=7.9999999999999998e-12
Xc1_IO_L3N_T0_DQS_AD5N_35 n1 c1_IO_L3N_T0_DQS_AD5N_35_din c1_IO_L3N_T0_DQS_AD5N_35_und 0 0 0 n10 0 dio_pin cpin=7.9999999999999998e-12
Xc1_IO_L3N_T0_DQS_EMCCLK_14 n1 c1_IO_L3N_T0_DQS_EMCCLK_14_din c1_IO_L3N_T0_DQS_EMCCLK_14_und 0 0 0 n7 0 dio_pin cpin=7.9999999999999998e-12
Xc1_IO_L3P_T0_DQS_34 n1 c1_IO_L3P_T0_DQS_34_din c1_IO_L3P_T0_DQS_34_und 0 0 0 n9 0 dio_pin cpin=7.9999999999999998e-12
Xc1_IO_L3P_T0_DQS_AD1P_15 n1 c1_IO_L3P_T0_DQS_AD1P_15_din c1_IO_L3P_T0_DQS_AD1P_15_und 0 0 0 n8 0 dio_pin cpin=7.9999999999999998e-12
Xc1_IO_L3P_T0_DQS_AD5P_35 n1 c1_IO_L3P_T0_DQS_AD5P_35_din c1_IO_L3P_T0_DQS_AD5P_35_und 0 0 0 n10 0 dio_pin cpin=7.9999999999999998e-12
Xc1_IO_L3P_T0_DQS_PUDC_B_14 n7 c1_IO_L3P_T0_DQS_PUDC_B_14_din c1_IO_L3P_T0_DQS_PUDC_B_14_und 0 0 0 n7 0 dio_pin cpin=7.9999999999999998e-12
Xc1_IO_L4N_T0_15 n1 c1_IO_L4N_T0_15_din c1_IO_L4N_T0_15_und 0 0 0 n8 0 dio_pin cpin=7.9999999999999998e-12
Xc1_IO_L4N_T0_34 n1 c1_IO_L4N_T0_34_din c1_IO_L4N_T0_34_und 0 0 0 n9 0 dio_pin cpin=7.9999999999999998e-12
Xc1_IO_L4N_T0_35 n1 c1_IO_L4N_T0_35_din c1_IO_L4N_T0_35_und 0 0 0 n10 0 dio_pin cpin=7.9999999999999998e-12
Xc1_IO_L4N_T0_D05_14 n1 c1_IO_L4N_T0_D05_14_din c1_IO_L4N_T0_D05_14_und 0 0 0 n7 0 dio_pin cpin=7.9999999999999998e-12
Xc1_IO_L4P_T0_15 n1 c1_IO_L4P_T0_15_din c1_IO_L4P_T0_15_und 0 0 0 n8 0 dio_pin cpin=7.9999999999999998e-12
Xc1_IO_L4P_T0_34 n1 c1_IO_L4P_T0_34_din c1_IO_L4P_T0_34_und 0 0 0 n9 0 dio_pin cpin=7.9999999999999998e-12
Xc1_IO_L4P_T0_35 n1 c1_IO_L4P_T0_35_din c1_IO_L4P_T0_35_und 0 0 0 n10 0 dio_pin cpin=7.9999999999999998e-12
Xc1_IO_L4P_T0_D04_14 n1 c1_IO_L4P_T0_D04_14_din c1_IO_L4P_T0_D04_14_und 0 0 0 n7 0 dio_pin cpin=7.9999999999999998e-12
Xc1_IO_L5N_T0_34 n1 c1_IO_L5N_T0_34_din c1_IO_L5N_T0_34_und 0 0 0 n9 0 dio_pin cpin=7.9999999999999998e-12
Xc1_IO_L5N_T0_AD13N_35 n1 c1_IO_L5N_T0_AD13N_35_din c1_IO_L5N_T0_AD13N_35_und 0 0 0 n10 0 dio_pin cpin=7.9999999999999998e-12
Xc1_IO_L5N_T0_AD9N_15 n1 c1_IO_L5N_T0_AD9N_15_din c1_IO_L5N_T0_AD9N_15_und 0 0 0 n8 0 dio_pin cpin=7.9999999999999998e-12
Xc1_IO_L5N_T0_D07_14 n1 c1_IO_L5N_T0_D07_14_din c1_IO_L5N_T0_D07_14_und 0 0 0 n7 0 dio_pin cpin=7.9999999999999998e-12
Xc1_IO_L5P_T0_34 n1 c1_IO_L5P_T0_34_din c1_IO_L5P_T0_34_und 0 0 0 n9 0 dio_pin cpin=7.9999999999999998e-12
Xc1_IO_L5P_T0_AD13P_35 n1 c1_IO_L5P_T0_AD13P_35_din c1_IO_L5P_T0_AD13P_35_und 0 0 0 n10 0 dio_pin cpin=7.9999999999999998e-12
Xc1_IO_L5P_T0_AD9P_15 n1 c1_IO_L5P_T0_AD9P_15_din c1_IO_L5P_T0_AD9P_15_und 0 0 0 n8 0 dio_pin cpin=7.9999999999999998e-12
Xc1_IO_L5P_T0_D06_14 n1 c1_IO_L5P_T0_D06_14_din c1_IO_L5P_T0_D06_14_und 0 0 0 n7 0 dio_pin cpin=7.9999999999999998e-12
Xc1_IO_L6N_T0_D08_VREF_14 n1 c1_IO_L6N_T0_D08_VREF_14_din c1_IO_L6N_T0_D08_VREF_14_und 0 0 0 n7 0 dio_pin cpin=7.9999999999999998e-12
Xc1_IO_L6N_T0_VREF_15 n1 c1_IO_L6N_T0_VREF_15_din c1_IO_L6N_T0_VREF_15_und 0 0 0 n8 0 dio_pin cpin=7.9999999999999998e-12
Xc1_IO_L6N_T0_VREF_34 n1 c1_IO_L6N_T0_VREF_34_din c1_IO_L6N_T0_VREF_34_und 0 0 0 n9 0 dio_pin cpin=7.9999999999999998e-12
Xc1_IO_L6N_T0_VREF_35 n1 c1_IO_L6N_T0_VREF_35_din c1_IO_L6N_T0_VREF_35_und 0 0 0 n10 0 dio_pin cpin=7.9999999999999998e-12
Xc1_IO_L6P_T0_15 n1 c1_IO_L6P_T0_15_din c1_IO_L6P_T0_15_und 0 0 0 n8 0 dio_pin cpin=7.9999999999999998e-12
Xc1_IO_L6P_T0_34 n1 c1_IO_L6P_T0_34_din c1_IO_L6P_T0_34_und 0 0 0 n9 0 dio_pin cpin=7.9999999999999998e-12
Xc1_IO_L6P_T0_35 n1 c1_IO_L6P_T0_35_din c1_IO_L6P_T0_35_und 0 0 0 n10 0 dio_pin cpin=7.9999999999999998e-12
Xc1_IO_L6P_T0_FCS_B_14 n1 c1_IO_L6P_T0_FCS_B_14_din c1_IO_L6P_T0_FCS_B_14_und 0 0 0 n7 0 dio_pin cpin=7.9999999999999998e-12
Xc1_IO_L7N_T1_34 n1 c1_IO_L7N_T1_34_din c1_IO_L7N_T1_34_und 0 0 0 n9 0 dio_pin cpin=7.9999999999999998e-12
Xc1_IO_L7N_T1_AD2N_15 n1 c1_IO_L7N_T1_AD2N_15_din c1_IO_L7N_T1_AD2N_15_und 0 0 0 n8 0 dio_pin cpin=7.9999999999999998e-12
Xc1_IO_L7N_T1_AD6N_35 n1 c1_IO_L7N_T1_AD6N_35_din c1_IO_L7N_T1_AD6N_35_und 0 0 0 n10 0 dio_pin cpin=7.9999999999999998e-12
Xc1_IO_L7N_T1_D10_14 n1 c1_IO_L7N_T1_D10_14_din c1_IO_L7N_T1_D10_14_und 0 0 0 n7 0 dio_pin cpin=7.9999999999999998e-12
Xc1_IO_L7P_T1_34 n1 c1_IO_L7P_T1_34_din c1_IO_L7P_T1_34_und 0 0 0 n9 0 dio_pin cpin=7.9999999999999998e-12
Xc1_IO_L7P_T1_AD2P_15 n1 c1_IO_L7P_T1_AD2P_15_din c1_IO_L7P_T1_AD2P_15_und 0 0 0 n8 0 dio_pin cpin=7.9999999999999998e-12
Xc1_IO_L7P_T1_AD6P_35 n1 c1_IO_L7P_T1_AD6P_35_din c1_IO_L7P_T1_AD6P_35_und 0 0 0 n10 0 dio_pin cpin=7.9999999999999998e-12
Xc1_IO_L7P_T1_D09_14 n1 c1_IO_L7P_T1_D09_14_din c1_IO_L7P_T1_D09_14_und 0 0 0 n7 0 dio_pin cpin=7.9999999999999998e-12
Xc1_IO_L8N_T1_34 n1 c1_IO_L8N_T1_34_din c1_IO_L8N_T1_34_und 0 0 0 n9 0 dio_pin cpin=7.9999999999999998e-12
Xc1_IO_L8N_T1_AD10N_15 n1 c1_IO_L8N_T1_AD10N_15_din c1_IO_L8N_T1_AD10N_15_und 0 0 0 n8 0 dio_pin cpin=7.9999999999999998e-12
Xc1_IO_L8N_T1_AD14N_35 n1 c1_IO_L8N_T1_AD14N_35_din c1_IO_L8N_T1_AD14N_35_und 0 0 0 n10 0 dio_pin cpin=7.9999999999999998e-12
Xc1_IO_L8N_T1_D12_14 n1 c1_IO_L8N_T1_D12_14_din c1_IO_L8N_T1_D12_14_und 0 0 0 n7 0 dio_pin cpin=7.9999999999999998e-12
Xc1_IO_L8P_T1_34 n1 c1_IO_L8P_T1_34_din c1_IO_L8P_T1_34_und 0 0 0 n9 0 dio_pin cpin=7.9999999999999998e-12
Xc1_IO_L8P_T1_AD10P_15 n1 c1_IO_L8P_T1_AD10P_15_din c1_IO_L8P_T1_AD10P_15_und 0 0 0 n8 0 dio_pin cpin=7.9999999999999998e-12
Xc1_IO_L8P_T1_AD14P_35 n1 c1_IO_L8P_T1_AD14P_35_din c1_IO_L8P_T1_AD14P_35_und 0 0 0 n10 0 dio_pin cpin=7.9999999999999998e-12
Xc1_IO_L8P_T1_D11_14 n1 c1_IO_L8P_T1_D11_14_din c1_IO_L8P_T1_D11_14_und 0 0 0 n7 0 dio_pin cpin=7.9999999999999998e-12
Xc1_IO_L9N_T1_DQS_34 n1 c1_IO_L9N_T1_DQS_34_din c1_IO_L9N_T1_DQS_34_und 0 0 0 n9 0 dio_pin cpin=7.9999999999999998e-12
Xc1_IO_L9N_T1_DQS_AD3N_15 n1 c1_IO_L9N_T1_DQS_AD3N_15_din c1_IO_L9N_T1_DQS_AD3N_15_und 0 0 0 n8 0 dio_pin cpin=7.9999999999999998e-12
Xc1_IO_L9N_T1_DQS_AD7N_35 n1 c1_IO_L9N_T1_DQS_AD7N_35_din c1_IO_L9N_T1_DQS_AD7N_35_und 0 0 0 n10 0 dio_pin cpin=7.9999999999999998e-12
Xc1_IO_L9N_T1_DQS_D13_14 n1 c1_IO_L9N_T1_DQS_D13_14_din c1_IO_L9N_T1_DQS_D13_14_und 0 0 0 n7 0 dio_pin cpin=7.9999999999999998e-12
Xc1_IO_L9P_T1_DQS_14 n1 c1_IO_L9P_T1_DQS_14_din c1_IO_L9P_T1_DQS_14_und 0 0 0 n7 0 dio_pin cpin=7.9999999999999998e-12
Xc1_IO_L9P_T1_DQS_34 n1 c1_IO_L9P_T1_DQS_34_din c1_IO_L9P_T1_DQS_34_und 0 0 0 n9 0 dio_pin cpin=7.9999999999999998e-12
Xc1_IO_L9P_T1_DQS_AD3P_15 n1 c1_IO_L9P_T1_DQS_AD3P_15_din c1_IO_L9P_T1_DQS_AD3P_15_und 0 0 0 n8 0 dio_pin cpin=7.9999999999999998e-12
Xc1_IO_L9P_T1_DQS_AD7P_35 n1 c1_IO_L9P_T1_DQS_AD7P_35_din c1_IO_L9P_T1_DQS_AD7P_35_und 0 0 0 n10 0 dio_pin cpin=7.9999999999999998e-12
* BEH-IC-DIGITAL-IO: electrical interface of a digital pin of an MCU / serial EEPROM (L2 pad model; the firmware/protocol behaviour is L3 and NOT simulated).
* pad din dout oe vcc gnd : pad = package pin; dout/oe = normalised (0..1, as node voltages) data and output-enable from a higher layer; din = normalised receive level (0..1) + 'und' flag node
* Input: Cpin, leakage, ESD clamps to rails; decision regions VIL = vilf*Vcc, VIH = vihf*Vcc, 'und' = 1 between them (undefined input level -> simulator should flag).
* Output: push-pull Thevenin roh/rol, hi-Z with leakage when oe=0; optional pull-up (rpu) when pu=1 and oe=0.
.model dpad d(is=1e-14 n=1 rs=5)
.subckt dio_pin pad din und dout oe pu vcc gndport params: vilf=0.3 vihf=0.6 roh=40 rol=20 cpin=4p ileak=1u rpu=35k
Cp pad gndport {cpin}
Dh pad vcc dpad
Dl gndport pad dpad
Bleak pad gndport I=(1-v(oe))*{ileak}*tanh((v(pad)-v(gndport))/0.1)*0.0
Bin din gndport V=0.5*(1+tanh((v(pad)-(v(gndport)+0.5*({vilf}+{vihf})*(v(vcc)-v(gndport))))/(0.02*(v(vcc)-v(gndport)))))
Bun und gndport V=0.25*(1+tanh((v(pad)-(v(gndport)+{vilf}*(v(vcc)-v(gndport))))/0.05))*(1-tanh((v(pad)-(v(gndport)+{vihf}*(v(vcc)-v(gndport))))/0.05))
Bth pad gndport I=v(oe)*(v(pad)-(v(gndport)+v(dout)*(v(vcc)-v(gndport))))/({roh}*v(dout)+{rol}*(1-v(dout)))
Bsup vcc gndport I=v(oe)*max(((v(gndport)+v(dout)*(v(vcc)-v(gndport)))-v(pad))/({roh}*v(dout)+{rol}*(1-v(dout))),0)
Bpu vcc pad I=(1-v(oe))*v(pu)*(v(vcc)-v(pad))/{rpu}
.ends

.op
.print op
.end
