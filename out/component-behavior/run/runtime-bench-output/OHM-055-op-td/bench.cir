OHMNI sourced behavior circuit
.options tnom=25
.temp 25
Iexcitation1 0 n1 DC 0.0080000000000000002
Rc1_td n1 0 0.59999999999999998
Rc1_rd 0 0 0.59999999999999998
Rc1_tx 0 0 1.1000000000000001
Rc1_rx 0 0 1.1000000000000001
.op
.print op
.end
