OHMNI sourced behavior circuit
.options tnom=25
.temp 25
Iexcitation1 0 n1 DC 0.5
Rc1_c1 n1 0 0.02
Rc1_c2 0 0 0.02
Rc1_c3 0 0 0.02
Rc1_c4 0 0 0.02
Rc1_c5 0 0 0.02
Rc1_c6 0 0 0.02
Rc1_c7 0 0 0.02
Rc1_c8 0 0 0.02
Rc1_c9 0 0 0.02
Rc1_c10 0 0 0.02
Rc1_c11 0 0 0.02
Rc1_c12 0 0 0.02
Rc1_c13 0 0 0.02
Rc1_c14 0 0 0.02
Rc1_c15 0 0 0.02
Rc1_c16 0 0 0.02
Rc1_c17 0 0 0.02
Rc1_c18 0 0 0.02
Rc1_c19 0 0 0.02
.op
.print op
.end
