OHMNI sourced behavior circuit
.options tnom=25
.temp 25
Vsource2 n2 0 DC 5
Rc1_2 0 n2 10000
Rc1_3 0 n2 10000
Rc1_4 0 n2 10000
Rc1_5 0 n2 10000
Rc1_6 0 n2 10000
Rc1_7 0 n2 10000
Rc1_8 0 n2 10000
.op
.print op
.end
