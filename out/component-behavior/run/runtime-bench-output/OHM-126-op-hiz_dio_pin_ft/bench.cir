OHMNI sourced behavior circuit
.options tnom=25
.temp 25
Vsource2 n2 0 DC 0
Vsource3 n3 0 DC 3.6000000000000001
Vc1_pu c1_pu 0 DC 1
Xc1_NRST n1 c1_NRST_din c1_NRST_und 0 0 c1_pu n3 0 dio_pin cpin=4.9999999999999997e-12 rpu=40000 vihf=0.69999999999999996 vilf=0.29999999999999999
Xc1_PA0 n2 c1_PA0_din c1_PA0_und 0 0 0 n3 0 dio_pin_ft cpin=4.9999999999999997e-12 vihf=0.69999999999999996 vilf=0.29999999999999999
Xc1_PA1 n1 c1_PA1_din c1_PA1_und 0 0 0 n3 0 dio_pin_ft cpin=4.9999999999999997e-12 vihf=0.69999999999999996 vilf=0.29999999999999999
Xc1_PA10 n1 c1_PA10_din c1_PA10_und 0 0 0 n3 0 dio_pin_ft cpin=4.9999999999999997e-12 vihf=0.69999999999999996 vilf=0.29999999999999999
Xc1_PA11 n1 c1_PA11_din c1_PA11_und 0 0 0 n3 0 dio_pin_ft cpin=4.9999999999999997e-12 vihf=0.69999999999999996 vilf=0.29999999999999999
Xc1_PA12 n1 c1_PA12_din c1_PA12_und 0 0 0 n3 0 dio_pin_ft cpin=4.9999999999999997e-12 vihf=0.69999999999999996 vilf=0.29999999999999999
Xc1_PA2 n1 c1_PA2_din c1_PA2_und 0 0 0 n3 0 dio_pin_ft cpin=4.9999999999999997e-12 vihf=0.69999999999999996 vilf=0.29999999999999999
Xc1_PA3 n1 c1_PA3_din c1_PA3_und 0 0 0 n3 0 dio_pin_ft cpin=4.9999999999999997e-12 vihf=0.69999999999999996 vilf=0.29999999999999999
Xc1_PA4 n1 c1_PA4_din c1_PA4_und 0 0 0 n3 0 dio_pin cpin=4.9999999999999997e-12 vihf=0.69999999999999996 vilf=0.29999999999999999
Xc1_PA5 n1 c1_PA5_din c1_PA5_und 0 0 0 n3 0 dio_pin cpin=4.9999999999999997e-12 vihf=0.69999999999999996 vilf=0.29999999999999999
Xc1_PA6 n1 c1_PA6_din c1_PA6_und 0 0 0 n3 0 dio_pin_ft cpin=4.9999999999999997e-12 vihf=0.69999999999999996 vilf=0.29999999999999999
Xc1_PA7 n1 c1_PA7_din c1_PA7_und 0 0 0 n3 0 dio_pin_ft cpin=4.9999999999999997e-12 vihf=0.69999999999999996 vilf=0.29999999999999999
Xc1_PA8 n1 c1_PA8_din c1_PA8_und 0 0 0 n3 0 dio_pin_ft cpin=4.9999999999999997e-12 vihf=0.69999999999999996 vilf=0.29999999999999999
Xc1_PA9 n1 c1_PA9_din c1_PA9_und 0 0 0 n3 0 dio_pin_ft cpin=4.9999999999999997e-12 vihf=0.69999999999999996 vilf=0.29999999999999999
Xc1_PB0 n1 c1_PB0_din c1_PB0_und 0 0 0 n3 0 dio_pin_ft cpin=4.9999999999999997e-12 vihf=0.69999999999999996 vilf=0.29999999999999999
Xc1_PB1 n1 c1_PB1_din c1_PB1_und 0 0 0 n3 0 dio_pin_ft cpin=4.9999999999999997e-12 vihf=0.69999999999999996 vilf=0.29999999999999999
Xc1_PB10 n1 c1_PB10_din c1_PB10_und 0 0 0 n3 0 dio_pin_ft cpin=4.9999999999999997e-12 vihf=0.69999999999999996 vilf=0.29999999999999999
Xc1_PB11 n1 c1_PB11_din c1_PB11_und 0 0 0 n3 0 dio_pin_ft cpin=4.9999999999999997e-12 vihf=0.69999999999999996 vilf=0.29999999999999999
Xc1_PB12 n1 c1_PB12_din c1_PB12_und 0 0 0 n3 0 dio_pin_ft cpin=4.9999999999999997e-12 vihf=0.69999999999999996 vilf=0.29999999999999999
Xc1_PB13 n1 c1_PB13_din c1_PB13_und 0 0 0 n3 0 dio_pin_ft cpin=4.9999999999999997e-12 vihf=0.69999999999999996 vilf=0.29999999999999999
Xc1_PB14 n1 c1_PB14_din c1_PB14_und 0 0 0 n3 0 dio_pin_ft cpin=4.9999999999999997e-12 vihf=0.69999999999999996 vilf=0.29999999999999999
Xc1_PB15 n1 c1_PB15_din c1_PB15_und 0 0 0 n3 0 dio_pin_ft cpin=4.9999999999999997e-12 vihf=0.69999999999999996 vilf=0.29999999999999999
Xc1_PB2 n1 c1_PB2_din c1_PB2_und 0 0 0 n3 0 dio_pin_ft cpin=4.9999999999999997e-12 vihf=0.69999999999999996 vilf=0.29999999999999999
Xc1_PB5 n1 c1_PB5_din c1_PB5_und 0 0 0 n3 0 dio_pin_ft cpin=4.9999999999999997e-12 vihf=0.69999999999999996 vilf=0.29999999999999999
Xc1_PB6 n1 c1_PB6_din c1_PB6_und 0 0 0 n3 0 dio_pin_ft cpin=4.9999999999999997e-12 vihf=0.69999999999999996 vilf=0.29999999999999999
Xc1_PB7 n1 c1_PB7_din c1_PB7_und 0 0 0 n3 0 dio_pin_ft cpin=4.9999999999999997e-12 vihf=0.69999999999999996 vilf=0.29999999999999999
Xc1_PB8 n1 c1_PB8_din c1_PB8_und 0 0 0 n3 0 dio_pin_ft cpin=4.9999999999999997e-12 vihf=0.69999999999999996 vilf=0.29999999999999999
Xc1_PB9 n1 c1_PB9_din c1_PB9_und 0 0 0 n3 0 dio_pin_ft cpin=4.9999999999999997e-12 vihf=0.69999999999999996 vilf=0.29999999999999999
Xc1_PC0 n1 c1_PC0_din c1_PC0_und 0 0 0 n3 0 dio_pin_ft cpin=4.9999999999999997e-12 vihf=0.69999999999999996 vilf=0.29999999999999999
Xc1_PC1 n1 c1_PC1_din c1_PC1_und 0 0 0 n3 0 dio_pin_ft cpin=4.9999999999999997e-12 vihf=0.69999999999999996 vilf=0.29999999999999999
Xc1_PC10 n1 c1_PC10_din c1_PC10_und 0 0 0 n3 0 dio_pin_ft cpin=4.9999999999999997e-12 vihf=0.69999999999999996 vilf=0.29999999999999999
Xc1_PC11 n1 c1_PC11_din c1_PC11_und 0 0 0 n3 0 dio_pin_ft cpin=4.9999999999999997e-12 vihf=0.69999999999999996 vilf=0.29999999999999999
Xc1_PC12 n1 c1_PC12_din c1_PC12_und 0 0 0 n3 0 dio_pin_ft cpin=4.9999999999999997e-12 vihf=0.69999999999999996 vilf=0.29999999999999999
Xc1_PC2 n1 c1_PC2_din c1_PC2_und 0 0 0 n3 0 dio_pin_ft cpin=4.9999999999999997e-12 vihf=0.69999999999999996 vilf=0.29999999999999999
Xc1_PC3 n1 c1_PC3_din c1_PC3_und 0 0 0 n3 0 dio_pin_ft cpin=4.9999999999999997e-12 vihf=0.69999999999999996 vilf=0.29999999999999999
Xc1_PC4 n1 c1_PC4_din c1_PC4_und 0 0 0 n3 0 dio_pin_ft cpin=4.9999999999999997e-12 vihf=0.69999999999999996 vilf=0.29999999999999999
Xc1_PC5 n1 c1_PC5_din c1_PC5_und 0 0 0 n3 0 dio_pin_ft cpin=4.9999999999999997e-12 vihf=0.69999999999999996 vilf=0.29999999999999999
Xc1_PC6 n1 c1_PC6_din c1_PC6_und 0 0 0 n3 0 dio_pin_ft cpin=4.9999999999999997e-12 vihf=0.69999999999999996 vilf=0.29999999999999999
Xc1_PC7 n1 c1_PC7_din c1_PC7_und 0 0 0 n3 0 dio_pin_ft cpin=4.9999999999999997e-12 vihf=0.69999999999999996 vilf=0.29999999999999999
Xc1_PC8 n1 c1_PC8_din c1_PC8_und 0 0 0 n3 0 dio_pin_ft cpin=4.9999999999999997e-12 vihf=0.69999999999999996 vilf=0.29999999999999999
Xc1_PC9 n1 c1_PC9_din c1_PC9_und 0 0 0 n3 0 dio_pin_ft cpin=4.9999999999999997e-12 vihf=0.69999999999999996 vilf=0.29999999999999999
Xc1_PD0 n1 c1_PD0_din c1_PD0_und 0 0 0 n3 0 dio_pin_ft cpin=4.9999999999999997e-12 vihf=0.69999999999999996 vilf=0.29999999999999999
Xc1_PD1 n1 c1_PD1_din c1_PD1_und 0 0 0 n3 0 dio_pin_ft cpin=4.9999999999999997e-12 vihf=0.69999999999999996 vilf=0.29999999999999999
Xc1_PD10 n1 c1_PD10_din c1_PD10_und 0 0 0 n3 0 dio_pin_ft cpin=4.9999999999999997e-12 vihf=0.69999999999999996 vilf=0.29999999999999999
Xc1_PD11 n1 c1_PD11_din c1_PD11_und 0 0 0 n3 0 dio_pin_ft cpin=4.9999999999999997e-12 vihf=0.69999999999999996 vilf=0.29999999999999999
Xc1_PD12 n1 c1_PD12_din c1_PD12_und 0 0 0 n3 0 dio_pin_ft cpin=4.9999999999999997e-12 vihf=0.69999999999999996 vilf=0.29999999999999999
Xc1_PD13 n1 c1_PD13_din c1_PD13_und 0 0 0 n3 0 dio_pin_ft cpin=4.9999999999999997e-12 vihf=0.69999999999999996 vilf=0.29999999999999999
Xc1_PD14 n1 c1_PD14_din c1_PD14_und 0 0 0 n3 0 dio_pin_ft cpin=4.9999999999999997e-12 vihf=0.69999999999999996 vilf=0.29999999999999999
Xc1_PD15 n1 c1_PD15_din c1_PD15_und 0 0 0 n3 0 dio_pin_ft cpin=4.9999999999999997e-12 vihf=0.69999999999999996 vilf=0.29999999999999999
Xc1_PD2 n1 c1_PD2_din c1_PD2_und 0 0 0 n3 0 dio_pin_ft cpin=4.9999999999999997e-12 vihf=0.69999999999999996 vilf=0.29999999999999999
Xc1_PD3 n1 c1_PD3_din c1_PD3_und 0 0 0 n3 0 dio_pin_ft cpin=4.9999999999999997e-12 vihf=0.69999999999999996 vilf=0.29999999999999999
Xc1_PD4 n1 c1_PD4_din c1_PD4_und 0 0 0 n3 0 dio_pin_ft cpin=4.9999999999999997e-12 vihf=0.69999999999999996 vilf=0.29999999999999999
Xc1_PD5 n1 c1_PD5_din c1_PD5_und 0 0 0 n3 0 dio_pin_ft cpin=4.9999999999999997e-12 vihf=0.69999999999999996 vilf=0.29999999999999999
Xc1_PD6 n1 c1_PD6_din c1_PD6_und 0 0 0 n3 0 dio_pin_ft cpin=4.9999999999999997e-12 vihf=0.69999999999999996 vilf=0.29999999999999999
Xc1_PD7 n1 c1_PD7_din c1_PD7_und 0 0 0 n3 0 dio_pin_ft cpin=4.9999999999999997e-12 vihf=0.69999999999999996 vilf=0.29999999999999999
Xc1_PD8 n1 c1_PD8_din c1_PD8_und 0 0 0 n3 0 dio_pin_ft cpin=4.9999999999999997e-12 vihf=0.69999999999999996 vilf=0.29999999999999999
Xc1_PD9 n1 c1_PD9_din c1_PD9_und 0 0 0 n3 0 dio_pin_ft cpin=4.9999999999999997e-12 vihf=0.69999999999999996 vilf=0.29999999999999999
Xc1_PE0 n1 c1_PE0_din c1_PE0_und 0 0 0 n3 0 dio_pin_ft cpin=4.9999999999999997e-12 vihf=0.69999999999999996 vilf=0.29999999999999999
Xc1_PE1 n1 c1_PE1_din c1_PE1_und 0 0 0 n3 0 dio_pin_ft cpin=4.9999999999999997e-12 vihf=0.69999999999999996 vilf=0.29999999999999999
Xc1_PE10 n1 c1_PE10_din c1_PE10_und 0 0 0 n3 0 dio_pin_ft cpin=4.9999999999999997e-12 vihf=0.69999999999999996 vilf=0.29999999999999999
Xc1_PE11 n1 c1_PE11_din c1_PE11_und 0 0 0 n3 0 dio_pin_ft cpin=4.9999999999999997e-12 vihf=0.69999999999999996 vilf=0.29999999999999999
Xc1_PE12 n1 c1_PE12_din c1_PE12_und 0 0 0 n3 0 dio_pin_ft cpin=4.9999999999999997e-12 vihf=0.69999999999999996 vilf=0.29999999999999999
Xc1_PE13 n1 c1_PE13_din c1_PE13_und 0 0 0 n3 0 dio_pin_ft cpin=4.9999999999999997e-12 vihf=0.69999999999999996 vilf=0.29999999999999999
Xc1_PE14 n1 c1_PE14_din c1_PE14_und 0 0 0 n3 0 dio_pin_ft cpin=4.9999999999999997e-12 vihf=0.69999999999999996 vilf=0.29999999999999999
Xc1_PE15 n1 c1_PE15_din c1_PE15_und 0 0 0 n3 0 dio_pin_ft cpin=4.9999999999999997e-12 vihf=0.69999999999999996 vilf=0.29999999999999999
Xc1_PE2 n1 c1_PE2_din c1_PE2_und 0 0 0 n3 0 dio_pin_ft cpin=4.9999999999999997e-12 vihf=0.69999999999999996 vilf=0.29999999999999999
Xc1_PE3 n1 c1_PE3_din c1_PE3_und 0 0 0 n3 0 dio_pin_ft cpin=4.9999999999999997e-12 vihf=0.69999999999999996 vilf=0.29999999999999999
Xc1_PE4 n1 c1_PE4_din c1_PE4_und 0 0 0 n3 0 dio_pin_ft cpin=4.9999999999999997e-12 vihf=0.69999999999999996 vilf=0.29999999999999999
Xc1_PE5 n1 c1_PE5_din c1_PE5_und 0 0 0 n3 0 dio_pin_ft cpin=4.9999999999999997e-12 vihf=0.69999999999999996 vilf=0.29999999999999999
Xc1_PE6 n1 c1_PE6_din c1_PE6_und 0 0 0 n3 0 dio_pin_ft cpin=4.9999999999999997e-12 vihf=0.69999999999999996 vilf=0.29999999999999999
Xc1_PE7 n1 c1_PE7_din c1_PE7_und 0 0 0 n3 0 dio_pin_ft cpin=4.9999999999999997e-12 vihf=0.69999999999999996 vilf=0.29999999999999999
Xc1_PE8 n1 c1_PE8_din c1_PE8_und 0 0 0 n3 0 dio_pin_ft cpin=4.9999999999999997e-12 vihf=0.69999999999999996 vilf=0.29999999999999999
Xc1_PE9 n1 c1_PE9_din c1_PE9_und 0 0 0 n3 0 dio_pin_ft cpin=4.9999999999999997e-12 vihf=0.69999999999999996 vilf=0.29999999999999999
Xc1_PF0 n1 c1_PF0_din c1_PF0_und 0 0 0 n3 0 dio_pin_ft cpin=4.9999999999999997e-12 vihf=0.69999999999999996 vilf=0.29999999999999999
Xc1_PF1 n1 c1_PF1_din c1_PF1_und 0 0 0 n3 0 dio_pin_ft cpin=4.9999999999999997e-12 vihf=0.69999999999999996 vilf=0.29999999999999999
Xc1_PF10 n1 c1_PF10_din c1_PF10_und 0 0 0 n3 0 dio_pin_ft cpin=4.9999999999999997e-12 vihf=0.69999999999999996 vilf=0.29999999999999999
Xc1_PF11 n1 c1_PF11_din c1_PF11_und 0 0 0 n3 0 dio_pin_ft cpin=4.9999999999999997e-12 vihf=0.69999999999999996 vilf=0.29999999999999999
Xc1_PF12 n1 c1_PF12_din c1_PF12_und 0 0 0 n3 0 dio_pin_ft cpin=4.9999999999999997e-12 vihf=0.69999999999999996 vilf=0.29999999999999999
Xc1_PF13 n1 c1_PF13_din c1_PF13_und 0 0 0 n3 0 dio_pin_ft cpin=4.9999999999999997e-12 vihf=0.69999999999999996 vilf=0.29999999999999999
Xc1_PF14 n1 c1_PF14_din c1_PF14_und 0 0 0 n3 0 dio_pin_ft cpin=4.9999999999999997e-12 vihf=0.69999999999999996 vilf=0.29999999999999999
Xc1_PF15 n1 c1_PF15_din c1_PF15_und 0 0 0 n3 0 dio_pin_ft cpin=4.9999999999999997e-12 vihf=0.69999999999999996 vilf=0.29999999999999999
Xc1_PF2 n1 c1_PF2_din c1_PF2_und 0 0 0 n3 0 dio_pin_ft cpin=4.9999999999999997e-12 vihf=0.69999999999999996 vilf=0.29999999999999999
Xc1_PF3 n1 c1_PF3_din c1_PF3_und 0 0 0 n3 0 dio_pin_ft cpin=4.9999999999999997e-12 vihf=0.69999999999999996 vilf=0.29999999999999999
Xc1_PF4 n1 c1_PF4_din c1_PF4_und 0 0 0 n3 0 dio_pin_ft cpin=4.9999999999999997e-12 vihf=0.69999999999999996 vilf=0.29999999999999999
Xc1_PF5 n1 c1_PF5_din c1_PF5_und 0 0 0 n3 0 dio_pin_ft cpin=4.9999999999999997e-12 vihf=0.69999999999999996 vilf=0.29999999999999999
Xc1_PF6 n1 c1_PF6_din c1_PF6_und 0 0 0 n3 0 dio_pin_ft cpin=4.9999999999999997e-12 vihf=0.69999999999999996 vilf=0.29999999999999999
Xc1_PF7 n1 c1_PF7_din c1_PF7_und 0 0 0 n3 0 dio_pin_ft cpin=4.9999999999999997e-12 vihf=0.69999999999999996 vilf=0.29999999999999999
Xc1_PF8 n1 c1_PF8_din c1_PF8_und 0 0 0 n3 0 dio_pin_ft cpin=4.9999999999999997e-12 vihf=0.69999999999999996 vilf=0.29999999999999999
Xc1_PF9 n1 c1_PF9_din c1_PF9_und 0 0 0 n3 0 dio_pin_ft cpin=4.9999999999999997e-12 vihf=0.69999999999999996 vilf=0.29999999999999999
Xc1_PG0 n1 c1_PG0_din c1_PG0_und 0 0 0 n3 0 dio_pin_ft cpin=4.9999999999999997e-12 vihf=0.69999999999999996 vilf=0.29999999999999999
Xc1_PG1 n1 c1_PG1_din c1_PG1_und 0 0 0 n3 0 dio_pin_ft cpin=4.9999999999999997e-12 vihf=0.69999999999999996 vilf=0.29999999999999999
Xc1_PG10 n1 c1_PG10_din c1_PG10_und 0 0 0 n3 0 dio_pin_ft cpin=4.9999999999999997e-12 vihf=0.69999999999999996 vilf=0.29999999999999999
Xc1_PG11 n1 c1_PG11_din c1_PG11_und 0 0 0 n3 0 dio_pin_ft cpin=4.9999999999999997e-12 vihf=0.69999999999999996 vilf=0.29999999999999999
Xc1_PG12 n1 c1_PG12_din c1_PG12_und 0 0 0 n3 0 dio_pin_ft cpin=4.9999999999999997e-12 vihf=0.69999999999999996 vilf=0.29999999999999999
Xc1_PG13 n1 c1_PG13_din c1_PG13_und 0 0 0 n3 0 dio_pin_ft cpin=4.9999999999999997e-12 vihf=0.69999999999999996 vilf=0.29999999999999999
Xc1_PG14 n1 c1_PG14_din c1_PG14_und 0 0 0 n3 0 dio_pin_ft cpin=4.9999999999999997e-12 vihf=0.69999999999999996 vilf=0.29999999999999999
Xc1_PG15 n1 c1_PG15_din c1_PG15_und 0 0 0 n3 0 dio_pin_ft cpin=4.9999999999999997e-12 vihf=0.69999999999999996 vilf=0.29999999999999999
Xc1_PG2 n1 c1_PG2_din c1_PG2_und 0 0 0 n3 0 dio_pin_ft cpin=4.9999999999999997e-12 vihf=0.69999999999999996 vilf=0.29999999999999999
Xc1_PG3 n1 c1_PG3_din c1_PG3_und 0 0 0 n3 0 dio_pin_ft cpin=4.9999999999999997e-12 vihf=0.69999999999999996 vilf=0.29999999999999999
Xc1_PG4 n1 c1_PG4_din c1_PG4_und 0 0 0 n3 0 dio_pin_ft cpin=4.9999999999999997e-12 vihf=0.69999999999999996 vilf=0.29999999999999999
Xc1_PG5 n1 c1_PG5_din c1_PG5_und 0 0 0 n3 0 dio_pin_ft cpin=4.9999999999999997e-12 vihf=0.69999999999999996 vilf=0.29999999999999999
Xc1_PG6 n1 c1_PG6_din c1_PG6_und 0 0 0 n3 0 dio_pin_ft cpin=4.9999999999999997e-12 vihf=0.69999999999999996 vilf=0.29999999999999999
Xc1_PG7 n1 c1_PG7_din c1_PG7_und 0 0 0 n3 0 dio_pin_ft cpin=4.9999999999999997e-12 vihf=0.69999999999999996 vilf=0.29999999999999999
Xc1_PG8 n1 c1_PG8_din c1_PG8_und 0 0 0 n3 0 dio_pin_ft cpin=4.9999999999999997e-12 vihf=0.69999999999999996 vilf=0.29999999999999999
Xc1_PG9 n1 c1_PG9_din c1_PG9_und 0 0 0 n3 0 dio_pin_ft cpin=4.9999999999999997e-12 vihf=0.69999999999999996 vilf=0.29999999999999999
Xc1_PH0 n1 c1_PH0_din c1_PH0_und 0 0 0 n3 0 dio_pin_ft cpin=4.9999999999999997e-12 vihf=0.69999999999999996 vilf=0.29999999999999999
Xc1_PH1 n1 c1_PH1_din c1_PH1_und 0 0 0 n3 0 dio_pin_ft cpin=4.9999999999999997e-12 vihf=0.69999999999999996 vilf=0.29999999999999999
* BEH-IC-DIGITAL-IO: electrical interface of a digital pin of an MCU / serial EEPROM (L2 pad model; the firmware/protocol behaviour is L3 and NOT simulated).
* pad din dout oe vcc gnd : pad = package pin; dout/oe = normalised (0..1, as node voltages) data and output-enable from a higher layer; din = normalised receive level (0..1) + 'und' flag node
* Input: Cpin, leakage, ESD clamps to rails; decision regions VIL = vilf*Vcc, VIH = vihf*Vcc, 'und' = 1 between them (undefined input level -> simulator should flag).
* Output: push-pull Thevenin roh/rol, hi-Z with leakage when oe=0; optional pull-up (rpu) when pu=1 and oe=0.
.model dpad d(is=1e-14 n=1 rs=5)
.subckt dio_pin pad din und dout oe pu vcc gndport params: vilf=0.3 vihf=0.6 roh=40 rol=20 cpin=4p ileak=1u rpu=35k
Cp pad gndport {cpin}
Dh pad vcc dpad
Dl gndport pad dpad
Bleak pad gndport I=(1-v(oe))*{ileak}*tanh((v(pad)-v(gndport))/0.1)*0.0
Bin din gndport V=0.5*(1+tanh((v(pad)-(v(gndport)+0.5*({vilf}+{vihf})*(v(vcc)-v(gndport))))/(0.02*(v(vcc)-v(gndport)))))
Bun und gndport V=0.25*(1+tanh((v(pad)-(v(gndport)+{vilf}*(v(vcc)-v(gndport))))/0.05))*(1-tanh((v(pad)-(v(gndport)+{vihf}*(v(vcc)-v(gndport))))/0.05))
Bth pad gndport I=v(oe)*(v(pad)-(v(gndport)+v(dout)*(v(vcc)-v(gndport))))/({roh}*v(dout)+{rol}*(1-v(dout)))
Bsup vcc gndport I=v(oe)*max(((v(gndport)+v(dout)*(v(vcc)-v(gndport)))-v(pad))/({roh}*v(dout)+{rol}*(1-v(dout))),0)
Bpu vcc pad I=(1-v(oe))*v(pu)*(v(vcc)-v(pad))/{rpu}
.ends

* D075 variant of the BEH-IC-DIGITAL-IO pad (docs/behavior/bench/ic-digital-io/dio.lib, sha256 d4ce6b4f07531da603c125789fad97b8cb9115c47a81aa2555dddbb897168bba).
* Identical except that the upper clamp diode Dh (pad to vcc) is removed. Used only where the bound source states that the pin has
* no clamp to its supply: STM32 five-volt-tolerant (FT) pins ('Positive injection is not possible on these I/Os', DS8626 Rev 12
* Table 12 note 3; DS5319 Rev 20 Table 7 note 3), and the AVR RESET input rated to +13.0 V. Firmware and protocol are L3 and not simulated.
.model dpad d(is=1e-14 n=1 rs=5)
.subckt dio_pin_ft pad din und dout oe pu vcc gndport params: vilf=0.3 vihf=0.6 roh=40 rol=20 cpin=4p ileak=1u rpu=35k
Cp pad gndport {cpin}
Dl gndport pad dpad
Bleak pad gndport I=(1-v(oe))*{ileak}*tanh((v(pad)-v(gndport))/0.1)*0.0
Bin din gndport V=0.5*(1+tanh((v(pad)-(v(gndport)+0.5*({vilf}+{vihf})*(v(vcc)-v(gndport))))/(0.02*(v(vcc)-v(gndport)))))
Bun und gndport V=0.25*(1+tanh((v(pad)-(v(gndport)+{vilf}*(v(vcc)-v(gndport))))/0.05))*(1-tanh((v(pad)-(v(gndport)+{vihf}*(v(vcc)-v(gndport))))/0.05))
Bth pad gndport I=v(oe)*(v(pad)-(v(gndport)+v(dout)*(v(vcc)-v(gndport))))/({roh}*v(dout)+{rol}*(1-v(dout)))
Bsup vcc gndport I=v(oe)*max(((v(gndport)+v(dout)*(v(vcc)-v(gndport)))-v(pad))/({roh}*v(dout)+{rol}*(1-v(dout))),0)
Bpu vcc pad I=(1-v(oe))*v(pu)*(v(vcc)-v(pad))/{rpu}
.ends

.op
.print op
.end
