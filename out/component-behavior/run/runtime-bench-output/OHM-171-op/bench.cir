OHMNI sourced behavior circuit
.options tnom=25
.temp 25
Iexcitation1 0 n1 DC 1
Rc1_s 0 0 0.050000000000000003
Rc1_t n1 0 0.050000000000000003
Rc1_r 0 0 0.050000000000000003
.op
.print op
.end
