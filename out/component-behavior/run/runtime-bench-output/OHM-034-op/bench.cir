OHMNI sourced behavior circuit
.options tnom=25
.temp 25
Iexcitation1 0 n1 DC 3.4999999999999999e-06
Rc1_esr n1 c1_cb 2.2000000000000002
Cc1 c1_cb 0 2.1999999999999999e-05
Rc1_lk c1_cb 0 4571428.5714285718
.op
.print op
.end
