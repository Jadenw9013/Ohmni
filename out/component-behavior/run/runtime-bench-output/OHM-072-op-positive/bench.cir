OHMNI sourced behavior circuit
.options tnom=25
.temp 25
Vsource4 n4 0 DC 10
Iexcitation1 n2 n1 DC 1
.subckt BRIDGE_c1 AC1 AC2 PLUS MINUS
D1 AC1 PLUS DBR_c1
D2 AC2 PLUS DBR_c1
D3 MINUS AC1 DBR_c1
D4 MINUS AC2 DBR_c1
.ends
.model DBR_c1 D (IS=1.9570000000000001e-06 N=2.786 RS=0.0068250000000000003 CJO=6.4999999999999995e-11 VJ=0.7 M=0.5 TT=3.0000000000000001e-06 BV=1100 IBV=5u)
Xc1 n4 0 n2 n1 BRIDGE_c1
.op
.print op
.end
