OHMNI sourced behavior circuit
.options tnom=25
.temp 25
Iexcitation1 0 n1 DC 0.02
Dc1A1 n2 0 SEG_c1
Dc1B1 n1 0 SEG_c1
Dc1C1 n2 0 SEG_c1
Dc1D1 n2 0 SEG_c1
Dc1E1 n2 0 SEG_c1
Dc1F1 n2 0 SEG_c1
Dc1G1 n2 0 SEG_c1
Dc1DP1 n2 0 SEG_c1
Dc1A2 n2 n2 SEG_c1
Dc1B2 n2 n2 SEG_c1
Dc1C2 n2 n2 SEG_c1
Dc1D2 n2 n2 SEG_c1
Dc1E2 n2 n2 SEG_c1
Dc1F2 n2 n2 SEG_c1
Dc1G2 n2 n2 SEG_c1
Dc1DP2 n2 n2 SEG_c1
.model SEG_c1 D (IS=4.2379999999999998e-14 N=3.0070000000000001 RS=0 CJO=30p VJ=1.0 M=0.33 TT=0 BV=15 IBV=10u EG=2.2 XTI=3)
.op
.print op
.end
