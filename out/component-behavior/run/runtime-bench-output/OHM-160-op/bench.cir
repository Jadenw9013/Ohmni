OHMNI sourced behavior circuit
.options tnom=25
.temp 25
Iexcitation1 0 n1 DC 16
Rc1_cl1 0 n1 0.02
Rc1_cl2 0 0 0.02
Rc1_cl3 0 0 0.02
.op
.print op
.end
