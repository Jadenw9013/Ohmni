OHMNI sourced behavior circuit
.options tnom=25
.temp 25
Vsource10 n10 0 DC 4.5
Iexcitation1 n1 0 DC 0.0040000000000000001
Iexcitation2 n3 0 DC 0.0040000000000000001
Iexcitation3 n5 0 DC 0.0040000000000000001
Iexcitation4 n7 0 DC 0.0040000000000000001
Iexcitation5 n10 n2 DC 0.0040000000000000001
Iexcitation6 n10 n4 DC 0.0040000000000000001
Iexcitation7 n10 n6 DC 0.0040000000000000001
Iexcitation8 n10 n8 DC 0.0040000000000000001
Xc1_dir n10 ndir_c1 n10 0 hcin ci=3.0000000000000001e-12
Xc1_oe 0 noe_c1 n10 0 hcin ci=3.0000000000000001e-12
Bc1_enab enab_c1 0 V=v(ndir_c1)*(1-v(noe_c1))
Bc1_enba enba_c1 0 V=(1-v(ndir_c1))*(1-v(noe_c1))
Xc1_senseA1 n10 nA1_c1 n10 0 hcin ci=4.9999999999999997e-12
Xc1_driveB1 nA1_c1 enab_c1 n1 n10 0 hcout roh=50 rol=65 td=1.04e-08 taue=6.4000000000000002e-09
Xc1_senseB1 n1 nB1_c1 n10 0 hcin ci=4.9999999999999997e-12
Xc1_driveA1 nB1_c1 enba_c1 n10 n10 0 hcout roh=50 rol=65 td=1.04e-08 taue=6.4000000000000002e-09
Xc1_senseA2 0 nA2_c1 n10 0 hcin ci=4.9999999999999997e-12
Xc1_driveB2 nA2_c1 enab_c1 n2 n10 0 hcout roh=50 rol=65 td=1.04e-08 taue=6.4000000000000002e-09
Xc1_senseB2 n2 nB2_c1 n10 0 hcin ci=4.9999999999999997e-12
Xc1_driveA2 nB2_c1 enba_c1 0 n10 0 hcout roh=50 rol=65 td=1.04e-08 taue=6.4000000000000002e-09
Xc1_senseA3 n10 nA3_c1 n10 0 hcin ci=4.9999999999999997e-12
Xc1_driveB3 nA3_c1 enab_c1 n3 n10 0 hcout roh=50 rol=65 td=1.04e-08 taue=6.4000000000000002e-09
Xc1_senseB3 n3 nB3_c1 n10 0 hcin ci=4.9999999999999997e-12
Xc1_driveA3 nB3_c1 enba_c1 n10 n10 0 hcout roh=50 rol=65 td=1.04e-08 taue=6.4000000000000002e-09
Xc1_senseA4 0 nA4_c1 n10 0 hcin ci=4.9999999999999997e-12
Xc1_driveB4 nA4_c1 enab_c1 n4 n10 0 hcout roh=50 rol=65 td=1.04e-08 taue=6.4000000000000002e-09
Xc1_senseB4 n4 nB4_c1 n10 0 hcin ci=4.9999999999999997e-12
Xc1_driveA4 nB4_c1 enba_c1 0 n10 0 hcout roh=50 rol=65 td=1.04e-08 taue=6.4000000000000002e-09
Xc1_senseA5 n10 nA5_c1 n10 0 hcin ci=4.9999999999999997e-12
Xc1_driveB5 nA5_c1 enab_c1 n5 n10 0 hcout roh=50 rol=65 td=1.04e-08 taue=6.4000000000000002e-09
Xc1_senseB5 n5 nB5_c1 n10 0 hcin ci=4.9999999999999997e-12
Xc1_driveA5 nB5_c1 enba_c1 n10 n10 0 hcout roh=50 rol=65 td=1.04e-08 taue=6.4000000000000002e-09
Xc1_senseA6 0 nA6_c1 n10 0 hcin ci=4.9999999999999997e-12
Xc1_driveB6 nA6_c1 enab_c1 n6 n10 0 hcout roh=50 rol=65 td=1.04e-08 taue=6.4000000000000002e-09
Xc1_senseB6 n6 nB6_c1 n10 0 hcin ci=4.9999999999999997e-12
Xc1_driveA6 nB6_c1 enba_c1 0 n10 0 hcout roh=50 rol=65 td=1.04e-08 taue=6.4000000000000002e-09
Xc1_senseA7 n10 nA7_c1 n10 0 hcin ci=4.9999999999999997e-12
Xc1_driveB7 nA7_c1 enab_c1 n7 n10 0 hcout roh=50 rol=65 td=1.04e-08 taue=6.4000000000000002e-09
Xc1_senseB7 n7 nB7_c1 n10 0 hcin ci=4.9999999999999997e-12
Xc1_driveA7 nB7_c1 enba_c1 n10 n10 0 hcout roh=50 rol=65 td=1.04e-08 taue=6.4000000000000002e-09
Xc1_senseA8 0 nA8_c1 n10 0 hcin ci=4.9999999999999997e-12
Xc1_driveB8 nA8_c1 enab_c1 n8 n10 0 hcout roh=50 rol=65 td=1.04e-08 taue=6.4000000000000002e-09
Xc1_senseB8 n8 nB8_c1 n10 0 hcin ci=4.9999999999999997e-12
Xc1_driveA8 nB8_c1 enba_c1 0 n10 0 hcout roh=50 rol=65 td=1.04e-08 taue=6.4000000000000002e-09
* BEH-IC-LOGIC-SEQ: 74HC595 and 74HC138 L2 models. Needs XSPICE (adc_bridge, dac_bridge, d_dff, d_inverter): ngspice 42 here is built with XSPICE.
* Pin order of every subckt = DIP/SOIC/TSSOP package pin order 1..N, so X-instances can be bound pin-for-pin.
.model dclamp d(is=1e-14 n=1 rs=5 cjo=0)
.model adcn adc_bridge(in_low=0.4 in_high=0.6 rise_delay=1n fall_delay=1n)
.model dacn dac_bridge(out_low=0 out_high=1 out_undef=0.5 t_rise=1n t_fall=1n)
.model dffm d_dff(clk_delay=12n set_delay=12n reset_delay=12n ic=0)
.model dinv d_inverter(rise_delay=1n fall_delay=1n)
* ---- input conditioner: Ci, ESD clamps, normalised decision (0..1) at Vcc/2 ----
.subckt hcin a n vcc gndport params: ci=5p
Cia a gndport {ci}
Dah a vcc dclamp
Dal gndport a dclamp
Bn n gndport V=0.5*(1+tanh((v(a)-(v(gndport)+0.5*(v(vcc)-v(gndport))))/0.05))
.ends
* ---- output cell: normalised s (0..1) + normalised enable en (1 = driven). Thevenin roh/rol, hi-Z leakage when en=0 ----
.subckt hcout s en y vcc gndport params: roh=50 rol=65 td=10.4n taue=6.4n gz=1n
Bsd0 sdd gndport V=min(max(v(s),0),1)
Rsd sdd d2 50
T1 d2 gndport d3 gndport Z0=50 TD={td}
Rtd d3 gndport 50
Bsh sh gndport V=2*v(d3)
Rsh sh sh2 {taue/1p}
Csh sh2 gndport 1p
Bth y gndport I=min(max(v(en),0),1)*(v(y)-(v(gndport)+min(max(v(sh2),0),1)*(v(vcc)-v(gndport))))/(roh*min(max(v(sh2),0),1)+rol*(1-min(max(v(sh2),0),1)))+(1-min(max(v(en),0),1))*gz*(v(y)-v(gndport))
Bsup vcc gndport I=min(max(v(en),0),1)*max(((v(gndport)+min(max(v(sh2),0),1)*(v(vcc)-v(gndport)))-v(y))/(roh*min(max(v(sh2),0),1)+rol*(1-min(max(v(sh2),0),1))),0)
Dyh y vcc dclamp
Dyl gndport y dclamp
.ends
* ---- 74HC595 : pins 1..16 = QB QC QD QE QF QG QH GND QH' SRCLR SRCLK RCLK OE SER QA VCC ----
.subckt hc595 qb qc qd qe qf qg qh gndport qhp srclr srclk rclk oe ser qa vcc params: cpd=400p icc0=8u
Xi1 srclr n_clr vcc gndport hcin
Xi2 srclk n_sck vcc gndport hcin
Xi3 rclk n_rck vcc gndport hcin
Xi4 oe n_oe vcc gndport hcin
Xi5 ser n_ser vcc gndport hcin
Aadc [n_clr n_sck n_rck n_ser n_oe] [d_clr d_sck d_rck d_ser d_oe] adcn
Ainv d_clr d_rst dinv
* shift register: stage1 = QA ... stage8 = QH
Asr1 d_ser d_sck NULL d_rst sr1 nsr1 dffm
Asr2 sr1 d_sck NULL d_rst sr2 nsr2 dffm
Asr3 sr2 d_sck NULL d_rst sr3 nsr3 dffm
Asr4 sr3 d_sck NULL d_rst sr4 nsr4 dffm
Asr5 sr4 d_sck NULL d_rst sr5 nsr5 dffm
Asr6 sr5 d_sck NULL d_rst sr6 nsr6 dffm
Asr7 sr6 d_sck NULL d_rst sr7 nsr7 dffm
Asr8 sr7 d_sck NULL d_rst sr8 nsr8 dffm
* storage register
Ast1 sr1 d_rck NULL NULL st1 nst1 dffm
Ast2 sr2 d_rck NULL NULL st2 nst2 dffm
Ast3 sr3 d_rck NULL NULL st3 nst3 dffm
Ast4 sr4 d_rck NULL NULL st4 nst4 dffm
Ast5 sr5 d_rck NULL NULL st5 nst5 dffm
Ast6 sr6 d_rck NULL NULL st6 nst6 dffm
Ast7 sr7 d_rck NULL NULL st7 nst7 dffm
Ast8 sr8 d_rck NULL NULL st8 nst8 dffm
Ainvoe d_oe d_oen dinv
Adac [st1 st2 st3 st4 st5 st6 st7 st8 sr8 d_oen] [a_s1 a_s2 a_s3 a_s4 a_s5 a_s6 a_s7 a_s8 a_s9 a_oen] dacn
* OE is active low: enable = NOT OE
Xo1 a_s1 a_oen qa vcc gndport hcout
Xo2 a_s2 a_oen qb vcc gndport hcout
Xo3 a_s3 a_oen qc vcc gndport hcout
Xo4 a_s4 a_oen qd vcc gndport hcout
Xo5 a_s5 a_oen qe vcc gndport hcout
Xo6 a_s6 a_oen qf vcc gndport hcout
Xo7 a_s7 a_oen qg vcc gndport hcout
Xo8 a_s8 a_oen qh vcc gndport hcout
Bone one gndport V=1
Xo9 a_s9 one qhp vcc gndport hcout
Bicc vcc gndport I={icc0}+0.5*cpd*(v(vcc)-v(gndport))*(abs(ddt(v(n_sck)))+abs(ddt(v(n_rck))))*0.5
.ends
* ---- 74HC138 : pins 1..16 = A B C G2A G2B G1 Y7 GND Y6 Y5 Y4 Y3 Y2 Y1 Y0 VCC ----
.subckt hc138 a b c g2a g2b g1 y7 gndport y6 y5 y4 y3 y2 y1 y0 vcc params: cpd=85p icc0=8u
Xa a na vcc gndport hcin
Xb b nb vcc gndport hcin
Xc c nc vcc gndport hcin
Xg1 g1 ng1 vcc gndport hcin
Xg2a g2a ng2a vcc gndport hcin
Xg2b g2b ng2b vcc gndport hcin
Ben en gndport V=v(ng1)*(1-v(ng2a))*(1-v(ng2b))
Bone one gndport V=1
* active-low outputs: Yn = 1 - en*match(n)
By0 l0 gndport V=1-v(en)*(1-v(na))*(1-v(nb))*(1-v(nc))
By1 l1 gndport V=1-v(en)*(v(na))*(1-v(nb))*(1-v(nc))
By2 l2 gndport V=1-v(en)*(1-v(na))*(v(nb))*(1-v(nc))
By3 l3 gndport V=1-v(en)*(v(na))*(v(nb))*(1-v(nc))
By4 l4 gndport V=1-v(en)*(1-v(na))*(1-v(nb))*(v(nc))
By5 l5 gndport V=1-v(en)*(v(na))*(1-v(nb))*(v(nc))
By6 l6 gndport V=1-v(en)*(1-v(na))*(v(nb))*(v(nc))
By7 l7 gndport V=1-v(en)*(v(na))*(v(nb))*(v(nc))
Xo0 l0 one y0 vcc gndport hcout
Xo1 l1 one y1 vcc gndport hcout
Xo2 l2 one y2 vcc gndport hcout
Xo3 l3 one y3 vcc gndport hcout
Xo4 l4 one y4 vcc gndport hcout
Xo5 l5 one y5 vcc gndport hcout
Xo6 l6 one y6 vcc gndport hcout
Xo7 l7 one y7 vcc gndport hcout
Bicc vcc gndport I={icc0}
.ends

.op
.print op
.end
