OHMNI sourced behavior circuit
.options tnom=25
.temp 25
Iexcitation1 0 n1 DC 10
Rc1 n1 0 0.0001
Rc1_e1 n3 n1 1u
Rc1_e2 n4 0 1u
.op
.print op
.end
