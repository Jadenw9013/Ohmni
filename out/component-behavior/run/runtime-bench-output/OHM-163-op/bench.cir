OHMNI sourced behavior circuit
.options tnom=25
.temp 25
Iexcitation1 0 n1 DC 1
Rc1_c1 n1 0 0.029999999999999999
Rc1_c2 0 0 0.029999999999999999
Rc1_c3 0 0 0.029999999999999999
Rc1_c4 0 0 0.029999999999999999
.op
.print op
.end
