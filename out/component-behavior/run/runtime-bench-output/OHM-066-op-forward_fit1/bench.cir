OHMNI sourced behavior circuit
.options tnom=25
.temp 25
Iexcitation1 0 n1 DC 0.01
Dc1 n1 0 DSS_c1
.model DSS_c1 D (IS=2.34e-06 N=1.0449999999999999 RS=0.0138 CJO=1.0000000000000001e-09 BV=40)
.op
.print op
.end
