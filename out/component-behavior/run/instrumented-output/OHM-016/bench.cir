OHMNI sourced behavior circuit
.options tnom=25
.temp 25
Vsource2 n2 0 DC 5
vprobe_c1_1 0 probe_c1_1 0
vprobe_c1_2 n2 probe_c1_2 0
vprobe_c1_3 n2 probe_c1_3 0
vprobe_c1_4 n2 probe_c1_4 0
vprobe_c1_5 n2 probe_c1_5 0
vprobe_c1_6 n2 probe_c1_6 0
vprobe_c1_7 n2 probe_c1_7 0
vprobe_c1_8 n2 probe_c1_8 0
Rc1_2 probe_c1_1 probe_c1_2 10000
Rc1_3 probe_c1_1 probe_c1_3 10000
Rc1_4 probe_c1_1 probe_c1_4 10000
Rc1_5 probe_c1_1 probe_c1_5 10000
Rc1_6 probe_c1_1 probe_c1_6 10000
Rc1_7 probe_c1_1 probe_c1_7 10000
Rc1_8 probe_c1_1 probe_c1_8 10000
.op
.print op
.end
