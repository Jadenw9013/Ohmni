OHMNI sourced behavior circuit
.options tnom=25
.temp 25
Iexcitation1 0 n2 DC 0.69999999999999996
vprobe_c1_1 n2 probe_c1_1 0
vprobe_c1_2 0 probe_c1_2 0
Rc1 probe_c1_1 probe_c1_2 0.17000000000000001
.op
.print op
.end
