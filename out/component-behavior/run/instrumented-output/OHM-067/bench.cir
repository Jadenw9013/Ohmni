OHMNI sourced behavior circuit
.options tnom=25
.temp 25
Iexcitation1 0 n1 DC 0.01
vprobe_c1_1 n1 probe_c1_1 0
vprobe_c1_2 0 probe_c1_2 0
Dc1 probe_c1_1 probe_c1_2 DBAT_c1
.model DBAT_c1 D (IS=2.117e-07 N=1 RS=2.7000000000000002 CJO=7.9999999999999998e-12 BV=56)
.op
.print op
.end
