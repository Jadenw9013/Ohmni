OHMNI sourced behavior circuit
.options tnom=25
.temp 25
Vsource3 n3 0 DC 3.2999999999999998
vprobe_c1_1 0 probe_c1_1 0
vprobe_c1_2 n3 probe_c1_2 0
vprobe_c1_3 n1 probe_c1_3 0
vprobe_c1_4 n3 probe_c1_4 0
Xc1 probe_c1_4 probe_c1_1 probe_c1_2 probe_c1_3 ohm_xo f0=20000000 ppm=25 tstart=0.0050000000000000001 icc=0.0038 rout=30 vmin=2.9700000000000002
* OHMNI packaged clock oscillator, L2 behavioural. Pins: vdd gnd oe out.
* f0 nominal Hz, ppm total static offset (init tol + temp + aging, user-set), tstart start-up delay (s),
* icc operating supply current (A), icc_sb standby current (A), rout CMOS output resistance, tr rise/fall time, vmin min supply for operation, vth_oe enable threshold fraction of VDD.
.subckt ohm_xo vdd gnd oe out f0=10meg ppm=0 tstart=5u icc=4.2m icc_sb=1u rout=30 tr=1n vmin=2.25 vth_oe=0.7
.param fa={f0*(1+ppm*1e-6)} pr={1/fa}
Vclk clk gnd PULSE(0 1 {tstart} {tr} {tr} {0.5*pr-tr} {pr})
* enabled when supply valid AND (oe floating-high or above threshold)
Bdrv drv gnd V = (V(vdd,gnd)>{vmin}) ? ((V(oe,gnd)>{vth_oe}*V(vdd,gnd)) ? V(vdd,gnd)*V(clk,gnd) : 0) : 0
Ro drv out {rout}
Bi vdd gnd I = (V(vdd,gnd)>{vmin}) ? ((V(oe,gnd)>{vth_oe}*V(vdd,gnd)) ? {icc} : {icc_sb}) : 0
.ends ohm_xo

.tran 9.9999999999999991e-05 0.0050199999999999993
.control
set numdgt=15
run
print v(n1)
quit
.endc
.end
