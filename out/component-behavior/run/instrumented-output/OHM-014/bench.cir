OHMNI sourced behavior circuit
.options tnom=25
.temp 25
Iexcitation1 0 n1 DC 10
vprobe_c1_1 n1 probe_c1_1 0
vprobe_c1_2 0 probe_c1_2 0
Rc1 probe_c1_1 probe_c1_2 0.0050000000000000001
.op
.print op
.end
