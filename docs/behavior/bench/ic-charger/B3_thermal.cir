* BEH-IC-CHARGER-SOT235 B3: thermal regulation. Rprog=2k (Ireg=500 mA), Vin=5 V, Vbat=3.7 V, SOT-23-5 thetaJA = 230 C/W (Microchip mirror extract, 4-layer).
* Unlimited: Pd = 1.3*0.5 = 0.65 W -> Tj = 25 + 230*0.65 = 174.5 C > 150 C shutdown threshold. Expected: limiter folds charge current back until Tj ~ 150 C: Pd_allow = (150-25)/230 = 0.543 W -> Ibat ~ 0.543/1.3 = 0.418 A.
* (thermal-limited current is the model's behaviour, the real part cycles/regulates in a datasheet-specific way: 150 C shutdown with 10 C hysteresis only is documented in the opened extract)
.include mcp73831.lib
Vdd vdd 0 5
Vb vbat 0 3.7
Rprog prog 0 2k
X1 vdd 0 prog vbat stat chg_cc_cv
Rst stat vdd 10k
.nodeset v(x1.tj)=140
.control
set noaskquit
op
let ibat = i(Vb)
echo RESULT ibat_A=$&ibat tj=$&v(x1.tj)
quit
.endc
.end
