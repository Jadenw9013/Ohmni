* BEH-IC-OPAMP B1: gain-bandwidth bench. LM358 parameters (TI SLOS068 extract: GBW 0.7 MHz typ, Aol 100 V/mV typ=100 dB)
* v2: scalars printed as 'name = value' (gain0_db_val, f3db_g10_hz); behavior unchanged
* Non-inverting G=10 (R 9k/1k), +-... single 5 V supply, input DC 0.2 V (output 2.0 V, inside swing); AC 1.
* Analytic: single-pole closed-loop -3 dB freq = GBW/G*(1+...) ~ GBW*beta = 700k/10 = 70.0 kHz ; DC gain 20 dB (lower by 1/(1+G/Aol)= -0.0009 dB)
.include opamp_gp.lib
Vcc vcc 0 5
Vin in 0 dc 0.2 ac 1
X1 in fb vcc 0 out opamp_gp aol=100k gbw=700k sr=0.3Meg vos=0 ib=0 ios=0
Rf out fb 9k
Rg fb gm 1k
Vb gm 0 dc 0
Rl out 0 100k
.ac dec 100 100 10Meg
.control
set noaskquit
run
meas ac g0 find vdb(out) at=100
let g3 = g0-3.0103
meas ac f3 when vdb(out)=g3 cross=1
echo gain0_db_val = $&g0
echo f3db_g10_hz = $&f3
quit
.endc
.end
