* BEH-IC-OPAMP B2: slew-rate bench. Unity-gain follower, 5 V supply, input step 0.5 -> 2.5 V (inside CM range V+ -1.5 = 3.5 V).
* Analytic: SR = 0.3 V/us (LM358 typ). 10..90 % rise of a 2 V step slew-limited: dv=1.6 V -> t = 1.6/0.3 = 5.33 us.
.include opamp_gp.lib
Vcc vcc 0 5
Vin in 0 pulse(0.5 2.5 2u 1n 1n 40u 100u)
X1 in out vcc 0 out opamp_gp aol=100k gbw=700k sr=0.3Meg vos=0 ib=0 ios=0
Rl out 0 100k
.tran 20n 30u
.control
set noaskquit
run
meas tran t10 when v(out)=0.66 cross=1
meas tran t90 when v(out)=2.26 cross=1
let sr = (2.26-0.66)/(t90-t10)/1e6
echo RESULT sr_v_per_us=$&sr
quit
.endc
.end
