* BEH-IC-LDO-SOT235 B1: dropout. TLV70033-class (3.3 V), Iload = 100 mA, Vin swept 2.8..4.2 V.
* v2: sweep points read with meas dc FIND AT (interpolated) and printed as 'name = value'; behavior unchanged
* Hard-knee ideal: Vout = min(3.3 - 0.04*0.1, Vin - 0.86*0.1) = min(3.296, Vin-0.086): 2.914 V @Vin 3.0, 3.296 V @3.8.
* The model uses a soft knee (harmonic combination of the regulation and dropout branches); exact solution of the implemented equations (python bisection, same formula): 2.9115 V @3.0, 3.2951 V @3.8 (1 Mohm feedback load included). Difference to hard knee <= 2.5 mV / 0.9 mV.
* NOTE: needs .nodeset v(out)=2.7 (the op solve is initial-guess sensitive without it).
* Datasheet anchor (TI SLVSA00E extract): VDO = 85 mV @100 mA for the 2.8 V option -> rdo=0.86 ohm used as proxy for 3.3 V.
.include tlv700.lib
Vin in 0 3.5
Ven en 0 3.5
X1 in 0 en out tlv700
Iload out 0 dc 100m
.nodeset v(x1.tj)=25 v(out)=2.7
.control
set noaskquit
dc Vin 2.8 4.2 0.01
meas dc va find v(out) at=3.0
meas dc vb find v(out) at=3.8
echo vout_vin3p0_v = $&va
echo vout_vin3p8_v = $&vb
quit
.endc
.end
