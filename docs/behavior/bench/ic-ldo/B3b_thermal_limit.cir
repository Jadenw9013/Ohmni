* BEH-IC-LDO-SOT235 B3b: thermal limiting in transient (Ta=70 C, Vin=5.5 V, 16.5 ohm load). Cth = 0.05 J/C (ASSUMED) -> tau = 235.9*0.05 = 11.8 s.
* v2: scalars printed as 'name = value' (tj_end_c, vout_end_v, tj_t5s_c); behavior unchanged
* Early transient (limiter inactive): Tj(5 s) = 70 + 104.3*(1-exp(-5/11.8)) = 106.0 C (Pd=0.4421 W, final 70+235.9*0.4421). Without limiting Tj would head to 174 C > 160 C. Expected: Tj ends within ~2 C of 160 C and Vout folds back (memoryless limiter).
.include tlv700.lib
Vin in 0 5.5
Ven en 0 5.5
X1 in 0 en out tlv700 ta=70
Rl out 0 16.5
Co out 0 1u ic=3.29
.ic v(out)=3.29
.tran 20m 120 uic
.control
set noaskquit
run
meas tran tjend find v(x1.tj) at=119
meas tran voend find v(out) at=119
meas tran t5 find v(x1.tj) at=5
echo tj_end_c = $&tjend
echo vout_end_v = $&voend
echo tj_t5s_c = $&t5
quit
.endc
.end
