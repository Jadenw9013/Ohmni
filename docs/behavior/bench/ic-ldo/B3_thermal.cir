* BEH-IC-LDO-SOT235 B3: self-heating and thermal limiting, SOT-23-5 (DDC) thetaJA = 235.9 degC/W (TI SLVSA00E extract). Vin = 5.5 V, resistive load 16.5 ohm (~200 mA).
* v2: scalars printed as 'name = value'; behavior unchanged
* (a) Ta=25: Pd = (Vin-Vout)*Iout + Vin*Ign  ->  Tj = Ta + 235.9*Pd. Check: Tj equals Ta + rth*Pd computed from the printed Vout, Iout (self consistency), expected ~129 C, below the 160 C limit.
* (b) Ta=70: the same dissipation would give Tj = 174 C > 160 C: the thermal limiter folds the current back so that Tj ~ 160 C (memoryless model; the real part cycles 160/140 C).
.include tlv700.lib
Vin in 0 5.5
Ven en 0 5.5
X1 in 0 en out tlv700 ta=25
Rl out 0 16.5
.nodeset v(x1.tj)=100 v(out)=3.2
.control
set noaskquit
op
let io = v(out)/16.5
let pd = (5.5-v(out))*io + 5.5*(31u+(270u-31u)*io/0.2)
let tjc = 25 + 235.9*pd
let vo = v(out)
let tjm = v(x1.tj)
echo a_vout_v = $&vo
echo a_iout_a = $&io
echo a_pd_w = $&pd
echo tj_model_c = $&tjm
echo tj_check_c = $&tjc
quit
.endc
.end
