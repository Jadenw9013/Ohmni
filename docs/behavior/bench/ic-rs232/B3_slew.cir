* BEH-IC-RS232-DIP16 B3: driver slew rate, 3 kohm + 2.5 nF load, TIN step. Datasheet (extract): 30 V/us.
* Datasheet SR = 30 V/us (extract). Model: slew-limited internal node (Imax = SR*1 nF) plus Ro=300 ohm into 100 pF (tau 30 ns). Measured 10..90 % rate is ~27 V/us (soft tanh knee + RC tail) -> within 10 % of 30.
.include max232.lib
Vcc vcc 0 5
Vt t1i 0 pwl(0 5 1u 5 1.001u 0 10u 0)
X1 c1p vsp c1m c2p c2m vsm t2o r2i r2o t2i t1i r1o r1i o1 0 vcc max232
Rl o1 0 3k
Cl o1 0 100p
Rg t2i 0 1k
Rg2 r2i 0 1k
Rg3 r1i 0 1k
.tran 2n 8u
.control
set noaskquit
run
meas tran v0 find v(o1) at=0.9u
meas tran v1 find v(o1) at=7u
let lo = v0 + 0.1*(v1-v0)
let hi = v0 + 0.9*(v1-v0)
meas tran ta when v(o1)=$&lo cross=1
meas tran tb when v(o1)=$&hi cross=1
let sr = (hi-lo)/(tb-ta)/1e6
echo RESULT v_low=$&v0 v_high=$&v1 sr_V_per_us=$&sr
quit
.endc
.end
