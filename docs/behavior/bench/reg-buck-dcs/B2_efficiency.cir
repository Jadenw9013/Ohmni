* BEH-REG-BUCK-DCS B2: efficiency at one load point. TEMPLATE: run_all.sh replaces @RL@ (ohm), @TSTOP@, @TAVG0@
* 12 V -> 3.3 V, TPS62160-style parameters. eta = Pout/Pin, Pin = 12*mean(-i(Vin)), Pout = mean(vout^2)/RL
* Analytic CCM (heavy load): Ploss = Iout^2*(D*RHS + (1-D)*RLS + DCR) + ripple term + IQ*Vin + 0.5*Csw*Vin^2*fsw
* Analytic DCM (light load): fsw ~ Iout/Qpulse, Qpulse = 0.5*Ipk*(tON+tfall)
.include buck_core.inc
Vin vin 0 12
Ven en 0 3.3
Xb vin 0 vout vout en BUCKCORE K=420n RHS=0.4 RLS=0.16 VSET=3.3 IQ=17u L=2.2u DCR=0.05
Cout vout 0 22u ic=3.3
Rl vout 0 @RL@
.options method=gear reltol=1e-3 abstol=1e-9 vntol=1e-5 gmin=1e-9
.tran 1n @TSTOP@ uic
.control
set noaskquit
run
let pin = -12*i(vin)
let pout = v(vout)*v(vout)/@RL@
meas tran pin_avg avg pin from=@TAVG0@ to=@TSTOP@
meas tran pout_avg avg pout from=@TAVG0@ to=@TSTOP@
meas tran vavg avg v(vout) from=@TAVG0@ to=@TSTOP@
meas tran tper5 trig v(xb.q) val=0.5 rise=2 targ v(xb.q) val=0.5 rise=7 from=@TAVG0@
let fsw = 5/tper5
let eta = pout_avg/pin_avg
print eta pin_avg pout_avg vavg fsw
quit
.endc
.end
