* BEH-REG-BUCK-DCS B2: efficiency at one fixed load point: RL = 3.3 ohm (Iout ~ 1 A), TSTOP = 80 us, averaging window 40..80 us (> 90 switching cycles)
* v2: former template (@RL@/@TSTOP@/@TAVG0@ placeholders substituted by run_all.sh) is now self-contained at RL=3.3 ohm, 80u, 40u; added eta_pct and fsw_khz scalars. The 10 mA point is bench B2b; run_all.sh no longer sed-substitutes.
* 12 V -> 3.3 V, TPS62160-style parameters. eta = Pout/Pin, Pin = 12*mean(-i(Vin)), Pout = mean(vout^2)/RL
* Analytic CCM (heavy load): Ploss = Iout^2*(D*RHS + (1-D)*RLS + DCR) + ripple term + IQ*Vin + 0.5*Csw*Vin^2*fsw
* Analytic DCM (light load): fsw ~ Iout/Qpulse, Qpulse = 0.5*Ipk*(tON+tfall)
.include buck_core.inc
Vin vin 0 12
Ven en 0 3.3
Xb vin 0 vout vout en BUCKCORE K=420n RHS=0.4 RLS=0.16 VSET=3.3 IQ=17u L=2.2u DCR=0.05
Cout vout 0 22u ic=3.3
Rl vout 0 3.3
.options method=gear reltol=1e-3 abstol=1e-9 vntol=1e-5 gmin=1e-9
.tran 1n 80u uic
.control
set noaskquit
run
let pin = -12*i(vin)
let pout = v(vout)*v(vout)/3.3
meas tran pin_avg avg pin from=40u to=80u
meas tran pout_avg avg pout from=40u to=80u
meas tran vavg avg v(vout) from=40u to=80u
meas tran tper5 trig v(xb.q) val=0.5 rise=2 targ v(xb.q) val=0.5 rise=7 from=40u
let fsw = 5/tper5
let eta = pout_avg/pin_avg
let eta_pct = eta*100
let fsw_khz = fsw/1e3
print eta_pct pin_avg pout_avg vavg fsw_khz
quit
.endc
.end
