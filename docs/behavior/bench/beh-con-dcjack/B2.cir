* B2 BEH-CON-DCJACK third (switch) contact: battery disconnects when plug inserted
* plug control voltage 0 = unplugged (switch closed), 1 = plugged (switch open)
* switch contact resistance 50 mohm (ASSUMPTION), tip contact 30 mohm (CUI), battery int. 0.1 ohm
Vplug plug 0 0
Vbat bat 0 9
Rbi bat p3 0.1
.model SWNC SW(Vt=0.5 Vh=0.1 Ron=0.05 Roff=1G)
* normally closed: closed when control below threshold -> use inverted control
Binv ninv 0 V = 1 - v(plug)
Rinv ninv 0 1G
S1 p3 p1 ninv 0 SWNC
Vadp adp 0 12
* adapter drives tip only while plugged
.model SWAD SW(Vt=0.5 Vh=0.1 Ron=0.03 Roff=1G)
S2 adp p1 plug 0 SWAD
RL p1 0 100
.control
dc Vplug 0 1 1
print v(p1) i(Vbat)
let e0 = 9*100/(100+0.1+0.05)
let e1 = 12*100/(100+0.03)
print e0 e1
.endc
.end
