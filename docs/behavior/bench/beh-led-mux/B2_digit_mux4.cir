* B2: 4-digit common-cathode multiplex (one lit segment per digit), digit-select switches Ron=10 ohm, 4 slots of 249 us in 1 ms
.include models.inc
.model SW1 SW(Ron=10 Roff=1G Vt=2.5 Vh=0.1)
VCC vcc 0 5
RSEG vcc seg 150
VSEG seg s2 0
VDIG0 g0 0 PULSE(0 5 0u 1n 1n 249u 1m)
VD0 s2 sd0 0
DSEG0 sd0 k0 LED_RED
S0 k0 0 g0 0 SW1
VDIG1 g1 0 PULSE(0 5 250u 1n 1n 249u 1m)
VD1 s2 sd1 0
DSEG1 sd1 k1 LED_RED
S1 k1 0 g1 0 SW1
VDIG2 g2 0 PULSE(0 5 500u 1n 1n 249u 1m)
VD2 s2 sd2 0
DSEG2 sd2 k2 LED_RED
S2 k2 0 g2 0 SW1
VDIG3 g3 0 PULSE(0 5 750u 1n 1n 249u 1m)
VD3 s2 sd3 0
DSEG3 sd3 k3 LED_RED
S3 k3 0 g3 0 SW1
.tran 2u 20m 0 2u
.meas tran iseg AVG i(VSEG) FROM=2m TO=20m
.meas tran idig AVG i(VD0) FROM=2m TO=20m
.meas tran ipk MAX i(VD0) FROM=2m TO=20m
.end
