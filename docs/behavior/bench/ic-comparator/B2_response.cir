* BEH-IC-COMPARATOR B2: response time, falling output, RL=5.1k to 5 V, CL=15 pF (TI test circuit conditions), Vos=0.
* v2: scalars printed as 'name = value'; behavior unchanged
* (a) 100 mV step with 5 mV overdrive: expect ~1.3 us (TI typ) -- calibration target
* (b) large (TTL-level) overdrive: expect ~0.3 us (TI typ) -- calibration target
* Model analytic: t = td + tau*ln(1+Vs/(A*vod)) = 0.3u + 1.44u*ln(1+1/(200*0.005)) = 1.298 us ; large overdrive 1.4 V: 0.3u+1.44u*ln(1+1/280)=0.305 us ; plus output edge ~ Ron*... small
.include lm393.lib
Vcc vcc 0 5
Vref ref 0 2.5
* (a): IN+ starts 100 mV above ref, steps to 5 mV below ref -> output goes low
Va ina 0 pwl(0 2.6 1u 2.6 1.001u 2.495 10u 2.495)
Xa ina ref vcc 0 outa comp_oc vos=0 ib=0 ios=0
Rla vcc outa 5.1k
Cla outa 0 15p
* (b): step 1.4 V overdrive
Vb inb 0 pwl(0 3.9 1u 3.9 1.001u 1.1 10u 1.1)
Xb inb ref vcc 0 outb comp_oc vos=0 ib=0 ios=0
Rlb vcc outb 5.1k
Clb outb 0 15p
.tran 5n 10u
.control
set noaskquit
run
meas tran ta trig v(ina) val=2.5 fall=1 targ v(outa) val=2.5 fall=1
meas tran tb trig v(inb) val=2.5 fall=1 targ v(outb) val=2.5 fall=1
let tau = ta*1e6
let tbb = tb*1e6
echo t_5mv_us = $&tau
echo t_ttl_us = $&tbb
quit
.endc
.end
