* BEH-IC-LOGIC-HC B4: Schmitt-trigger thresholds (74HC14 class), Vcc = 4.5 V, slow triangular input.
* v2: scalars printed as 'name = value'; behavior unchanged
* SCLS085L typ: VT+ = 2.5 V, VT- = 1.6 V (as extracted; min/max 1.55/3.13 and 0.9/2.45).  Calibration check.
.include hc_gates.lib
Vcc vcc 0 4.5
Vin in 0 pwl(0 0 10u 4.5 20u 0)
X1 in y vcc 0 hc_inv_st
Cl y 0 10p
.tran 10n 20u
.control
set noaskquit
run
meas tran tfall when v(y)=2.25 fall=1
meas tran trise when v(y)=2.25 rise=1
let vtp = 4.5*tfall/10u
let vtm = 4.5*(20u-trise)/10u
echo vt_plus_v = $&vtp
echo vt_minus_v = $&vtm
quit
.endc
.end
