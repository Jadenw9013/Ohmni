* BEH-IC-DRIVER-DIP16 B1: ULN2003A VCE(sat) at the three TI SLRS027T test points (base current forced with rb=1 mohm and a current source).
* v2: scalars printed as 'name = value'; behavior unchanged
* TI bands: 0.9..1.1 V @ IC=100 mA, II=250 uA ; 1.0..1.3 V @ 200 mA, 350 uA ; 1.2..1.6 V @ 350 mA, 500 uA. Fit targets (band mid): 0.99 / 1.15 / 1.40 V
.include drivers.lib
Vc vcc 0 5
Ia 0 ina dc 250u
Xa ina outa vcc 0 uln_ch rb=1m
Ica vcc outa dc 100m
Ib 0 inb dc 350u
Xb inb outb vcc 0 uln_ch rb=1m
Icb vcc outb dc 200m
Ic3 0 inc dc 500u
Xc inc outc vcc 0 uln_ch rb=1m
Icc vcc outc dc 350m
.control
set noaskquit
op
let va = v(outa)
let vb = v(outb)
let vc = v(outc)
echo vce_100ma_v = $&va
echo vce_200ma_v = $&vb
echo vce_350ma_v = $&vc
quit
.endc
.end
