* BEH-IC-DRIVER-DIP16 B2: (a) input current at VI=3.85 V (ULN2003A, 2.7k input) and VI=5 V; (b) inductive flyback: 10 mH + 50 ohm coil from 12 V = COM, on 3 ms then off.
* v2: scalars printed as 'name = value' (ii_3p85v_ma, ii_5v_ma, flyback_peak_v); behavior unchanged
* (a) Analytic estimate: II = (VI - 2 Vbe)/2.7k with 2*Vbe ~1.4 V -> 0.9 mA @3.85 V, 1.33 mA @5 V (circuit consistency; datasheet ULN2003A conditions are not in the opened extract, whose II rows look like ULN2004A (10.5k): 0.34 mA @5 V = (5-1.4)/10.5k)
* (b) Flyback peak on OUT = V(COM) + VF(IF ~ 0.22 A). Datasheet clamp VF 1.7..2.0 V at 350 mA. Expect OUT peak between 13.5 and 14.2 V.
.include drivers.lib
Vc vcc 0 12
Vi385 i1 0 3.85
X1 i1 o1 vcc 0 uln_ch
Rl1 vcc o1 50
Vi5 i2 0 5
X2 i2 o2 vcc 0 uln_ch
Rl2 vcc o2 50
* flyback
Vp inp 0 pwl(0 0 1m 0 1.001m 5 4m 5 4.001m 0)
Xf inp of vcc 0 uln_ch
Lf vcc mid 10m
Rf mid of 50
.tran 1u 8m
.control
set noaskquit
run
meas tran i385 find i(Vi385) at=0.1m
meas tran i5 find i(Vi5) at=0.1m
meas tran vpk max v(of) from=4m to=6m
let ii385 = abs(i385)*1000
let ii5 = abs(i5)*1000
echo ii_3p85v_ma = $&ii385
echo ii_5v_ma = $&ii5
echo flyback_peak_v = $&vpk
quit
.endc
.end
