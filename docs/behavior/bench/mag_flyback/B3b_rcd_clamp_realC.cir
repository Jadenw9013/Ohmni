B3b RCD clamp with realistic parasitics (Cds=10p, Dsn CJO=50p, CIW=10p): informational, shows the textbook relation overpredicts clamp power (Llk=2 uH = 2% of Lp, Coss+Cp lumped 220 pF = 200 pF Cds + 20 pF)
* Expected: P = 1/2*Llk*Ipk^2*f * Vc/(Vc-Vor) with Vc, Ipk, Vor=(Vout+0.45)/N all measured here (value computed in report); tolerance 15%
.include xfmr.lib
.model SW SW(Ron=5m Roff=1G Vt=2.5 Vh=0.1)
.model DSCH D(IS=1e-7 N=1.05 RS=20m CJO=50p)
Vin in 0 DC 48
Vg g 0 PULSE(0 5 0 5n 5n 2u 10u)
X1 in d 0 sa XFMR_SAT LP=100u N=0.5 LLK=2u RP=20m RS=40m CIW=10p ISATM=3 DROP=0.3 LR=0.05
S1 d 0 g 0 SW
Cds d 0 10p
Dsn d c DSCH
Csn c in 100n
Rsn c in 20k
D1 sa out DSCH
Co out 0 1u
RL out 0 100
.tran 100n 2.5m
.control
run
let vcl = v(c)-v(in)
let pclamp = vcl*vcl/20k
meas tran vdpk max v(d) from=2.2m to=2.5m
meas tran vout avg v(out) from=2.2m to=2.5m
meas tran ipk min i(Vin) from=2.2005m to=2.2021m
meas tran vc avg vcl from=2.2m to=2.5m
meas tran psn avg pclamp from=2.2m to=2.5m
quit
.endc
.end
