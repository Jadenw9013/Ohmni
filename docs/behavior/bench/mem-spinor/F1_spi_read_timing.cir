* BEH-MEM-SPINOR F1: stimulus + checker for an SPI mode-0 READ transaction: CS# low, 8-bit opcode, 24-bit address, N data bytes, CS# high.
* Required of an L3 flash model (SST25VF016B EOL supplement DS20005291A Table 3-2): SCK high/low >= 6 ns, CE# active setup TCES >= 5 ns, CE# high time TCPH >= 50 ns, data setup TDS >= 2 ns.
* Analytic: CS# low time = (8 + 24 + 8*N)/fSCK.   Case 0Bh high-speed read has 8 extra dummy clocks: (8+24+8+8N)/fSCK.
* This deck: fSCK = 25 MHz (40 ns period), opcode 03h, N = 256 bytes: (32 + 2048)*40 ns = 83.2 us plus the 10 ns lead-in (TCES) and 10 ns hold -> measured CS# low = 83.22 us expected.
* SCK is generated by a PULSE source gated by CS (B source); tCES = 10 ns lead-in.
.param TCK=40n
.param NB=256
.param NCLK={8+24+8*NB}
Vcs cs 0 PWL(0 3.3 100n 3.3 101n 0 {100n+10n+NCLK*TCK+10n} 0 {100n+10n+NCLK*TCK+11n} 3.3)
* SCK: PULSE(low high delay rise fall width period) delayed 110 ns after CS falls, NCLK pulses; gate by a window source
Vck0 ck0 0 PULSE(0 3.3 111n 0.5n 0.5n {TCK/2-0.5n} {TCK})
Bck ck 0 V = v(ck0)*(1-v(cs)/3.3)
.tran 1n {100n+10n+NCLK*TCK+200n}
.control
set noaskquit
run
meas tran tcs_low trig v(cs) val=1.65 fall=1 targ v(cs) val=1.65 rise=1
meas tran tces trig v(cs) val=1.65 fall=1 targ v(ck) val=1.65 rise=1
print tcs_low tces
quit
.endc
.end
