* B4: reverse leakage at 5 V (datasheet VR rating) and breakdown clamp of the LED model
* v2: added meas dc FIND at 5.5 V (= BV) and printed scalar ir_at_bv = -i(V1); dc sweep table print kept
.include models.inc
V1 a 0 DC 5
DB 0 a LED_BLUE
DR 0 a2 LED_RED
V2 a2 0 DC 5
.control
op
print i(V1) i(V2)
dc V1 5 7 0.25
print i(V1)
meas dc irbv_raw FIND i(V1) AT=5.5
let ir_at_bv = -irbv_raw
print ir_at_bv
quit
.endc
.end
