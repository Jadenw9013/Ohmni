* B3: PWM dimming: average LED current = duty * on-state current (red, 5 V, 150 ohm, 1 kHz, 25 percent)
.include models.inc
VP vs 0 PULSE(0 5 0 10n 10n 250u 1m)
R1 vs m 150
VS m a 0
DR a 0 LED_RED
.tran 1u 20m
.meas tran iavg AVG i(VS) FROM=2m TO=20m
.meas tran ipk MAX i(VS) FROM=2m TO=20m
.end
