B3 32.768 kHz tuning-fork crystal (Epson FC-135 class: C1=3.4f typ, C0=1.0p typ, R1<=70k, CL=12.5p). Expect fL=32768 Hz at CL=12.5p, Q=2*pi*fs*L1/R1=20.4k
.include ohm_xtal.lib
Iin 0 x dc 0 ac 1
X1 x y ohm_xtal L1=6940.181693751771 C1=3.4f R1=0.001 C0=1.0p
CLx y 0 12.5p
.control
ac lin 20001 32700 32800
let ph = vp(x)
meas ac fl WHEN ph=0 CROSS=1
quit
.endc
.end
