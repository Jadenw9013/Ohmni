B2 Load-capacitance pulling: frequency where X=0 with series CL (reactance zero crossing), CL = 12 15 18 pF
.include ohm_xtal.lib
.param cl=18p
Iin 0 x dc 0 ac 1
X1 x y ohm_xtal L1=43.99505512m C1=9f R1=0.001 C0=3p
CLx y 0 {cl}
.control
foreach c 8p 12p 15p 18p 22p 30p
  alter CLx = $c
  echo CL=$c
  ac lin 40001 7.995e6 8.02e6
  let ph = vp(x)
  meas ac fl WHEN ph=0 CROSS=1
end
quit
.endc
.end
