B1 BVD crystal impedance: series fs, parallel fa, ESR at fs (8 MHz, C1=9f C0=3p R1=80)
.include ohm_xtal.lib
Iin 0 x dc 0 ac 1
X1 x 0 ohm_xtal L1=43.99505512m C1=9f R1=80 C0=3p
.control
ac lin 40001 7.99e6 8.03e6
let zm = mag(v(x))
meas ac zmin MIN zm
meas ac fzmin MIN_AT zm
meas ac zmax MAX zm
meas ac fzmax MAX_AT zm
quit
.endc
.end
