* B4 full-speed device identification: device 1.5k on D+ to 3.3 V; host 15k pull-downs on D+ and D-
* Expected: V(D+) = 3.3*15k/(15k+1.5k) = 3.0 V ; V(D-) = 0 V ; unattached host: both 0 V
Vdev vdd 0 3.3
Rpu vdd dp 1.5k
Rhp dp 0 15k
Rhm dm 0 15k
Rdev_dm dm 0 1G
.op
.control
op
print v(dp) v(dm)
quit
.endc
.end
