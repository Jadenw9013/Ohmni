* RES-NETWORK B1: bussed SIP, common pin 1 to 5 V, 3 elements of 10k; pin2 pulled to gnd by 10k external -> V(p2)=2.5
* pin3 open -> V(p3)=5 V (no current). pin4 shorted to ground -> I = 0.5 mA
* Bussed topology: element k between pin1 (common) and pin k+1.
.subckt SIP4_BUSSED p1 p2 p3 p4 params: R=10k
R1 p1 p2 {R}
R2 p1 p3 {R}
R3 p1 p4 {R}
.ends
V1 c 0 5
Xn c p2 p3 p4 SIP4_BUSSED R=10k
Rext p2 0 10k
Rhi p3 0 1Meg
Vs p4 0 0
.control
set noaskquit
op
print v(p2)
print v(p3)
let i4 = -i(vs)
print i4
quit
.endc
.end
