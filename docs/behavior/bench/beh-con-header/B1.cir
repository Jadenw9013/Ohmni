* B1 contact resistance in a divider: mated connector, 2 contacts in series (signal + return)
* JST PH initial 10 mohm max per mated contact pair (S: JST PH spec). Load 1 ohm, 5 V.
.param Rc=10m Rl=1
.subckt conn_contact a b Rc=10m
Rcon a b {Rc}
.ends
Vs src 0 5
X1 src n1 conn_contact Rc={Rc}
Rload n1 n2 {Rl}
X2 n2 0 conn_contact Rc={Rc}
.op
.control
op
print v(n1) v(n2) i(Vs)
let vload = v(n1)-v(n2)
print vload
let expect = 5*1/(1+2*0.01)
print expect
quit
.endc
.end
