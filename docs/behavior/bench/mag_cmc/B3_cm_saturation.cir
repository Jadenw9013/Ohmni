B3 CMC saturation: DC common-mode current saturates, DC differential current does not (CMC_SAT, ISATM=1 A of total CM current: ASSUMPTION, datasheet gives no Isat)
* Expected Lcm(Ibias) = Ll/2 + Lm*(LR+(1-LR)*sech^2(Ibias/ia)), Ll=L(1-k), Lm=kL, ia=ISATM/atanh(sqrt(DROP/(1-LR)))
*   Ibias=0: 2.19997e-3 ; 1 A: 1.53999e-3 ; 2 A: 6.7515e-4 (python evaluation of the formula)
* Expected Ldm(Ibias, differential) unchanged = 1.3e-7
.include cmc.lib
Icm 0 c1 DC 0 AC 1
X1 c1 0 c1 0 CMC_SAT L=2.2m LS=130n RDC=0 C0=0 RPAR=1e12 ISATM=1 DROP=0.3 LR=0.05
Rg1 c1 0 1G
Idm 0 d1 DC 0 AC 1
X2 d1 dm d2 dm CMC_SAT L=2.2m LS=130n RDC=0 C0=0 RPAR=1e12 ISATM=1 DROP=0.3 LR=0.05
Rd2 d2 0 1u
Rg2 d1 0 1G
Rg3 dm 0 1G
.control
foreach ib 0 1 2
 alter Icm dc = $ib
 alter Idm dc = $ib
 ac lin 1 100k 100k
 let w = 2*pi*100k
 let lcm = imag(v(c1))/w
 let ldm = imag(v(d1)-v(d2))/w
 echo RESULT Ibias=$ib Lcm=$&lcm Ldm=$&ldm
end
quit
.endc
.end
