B1 CMC differential-mode vs common-mode inductance at 100 kHz (WE-SL5 744272222 values: L=2.2 mH, LS=130 nH typ)
* Expected: k = sqrt(1-LS/L) = 0.99997 ; Lcm = L(1+k)/2 = 2.2e-3 H (both windings paralleled in CM) ; Ldm = 2L(1-k) = 1.3e-7 H (loop through both windings)
.include cmc.lib
* CM test: a1,b1 tied to node c1 ; a2,b2 tied to ground
Icm 0 c1 DC 0 AC 1
X1 c1 0 c1 0 CMC_K L=2.2m LS=130n RDC=0 C0=0 RPAR=1e12
* DM test: current into a1, out of b1, windings joined a2-b2
Idm 0 d1 DC 0 AC 1
X2 d1 dm d2 dm CMC_K L=2.2m LS=130n RDC=0 C0=0 RPAR=1e12
Rd2 d2 0 1u
Rg1 c1 0 1G
Rg2 d1 0 1G
Rg3 dm 0 1G
* SAT-model copies with big ISATM must agree with the K model in the linear region
Icm2 0 e1 DC 0 AC 1
X3 e1 0 e1 0 CMC_SAT L=2.2m LS=130n RDC=0 C0=0 RPAR=1e12 ISATM=1000
Idm2 0 f1 DC 0 AC 1
X4 f1 fm f2 fm CMC_SAT L=2.2m LS=130n RDC=0 C0=0 RPAR=1e12 ISATM=1000
Rf2 f2 0 1u
Rg4 e1 0 1G
Rg5 f1 0 1G
Rg6 fm 0 1G
.ac lin 1 100k 100k
.control
run
let w = 2*pi*100k
let lcm = imag(v(c1))/w
let ldm_k = imag(v(d1)-v(d2))/w
let lcm_t = imag(v(e1))/w
let ldm_t = imag(v(f1)-v(f2))/w
echo RESULT Lcm_K=$&lcm Ldm_K=$&ldm_k Lcm_T=$&lcm_t Ldm_T=$&ldm_t
quit
.endc
.end
