* BEH-IC-DIGITAL-IF D3: power-on-reset release of a core rail as a threshold detector with hysteresis (behavioural S switch).
* Source: Lattice iCE40 LP/HX data sheet DS1040 v3.4 (extract): VCC ramp-up POR trip 0.55-0.75 V (LP640/1K/4K/8K & HX), ramp-down trip <= 0.75 V, supply ramp rate 0.40 .. 10 V/ms (min/max, extract formatting unclear).
* Model: ngspice SW turns ON at Vt+Vh (rising) and OFF at Vt-Vh (falling): Vt=0.64, Vh=0.01 -> release at 0.65 V rising (mid of 0.55-0.75), 0.63 V falling.
* Analytic: t_release = Vtrip_up / ramp = 0.65 V / 1000 V/s = 650 us. Tolerance 1 %.
Vcc vcc 0 PWL(0 0 1.2m 1.2 3m 1.2)
.model POR SW(Vt=0.64 Vh=0.01 Ron=1 Roff=1e9)
Spor pn 0 vcc 0 POR
* por_n = high when switch OFF (vcc below Vt). Invert: pull-up through R to 3.3 V, switch conducts when vcc>Vt -> por_n low = "released" convention for active-low reset:
Vpu pu 0 3.3
Rpu pu pn 10k
.tran 1u 3m
.control
set noaskquit
run
meas tran t_release when v(pn)=1.65 fall=1
print t_release
quit
.endc
.end
