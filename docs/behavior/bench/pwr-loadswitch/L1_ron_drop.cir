* BEH-PWR-LOADSWITCH L1: on-state drop. TPS22810 datasheet text: RON = 79 mOhm typical at VIN = 12 V; 3 A max continuous (DRV, TA = 65 C).
* v2: print only vdrop, pd, dt (already scalars); header only, circuit unchanged
* Analytic: V_drop = I*RON = 3.0*0.079 = 0.237 V ; P = I^2*RON = 0.711 W ; Tj rise with RthJA = 74.6 K/W (extract) = 53.0 K
.include loadsw.inc
Vin vin 0 12
Ven en 0 3.3
Xs vin vout 0 en LOADSW RON=0.079 ILIM=10 VUV=2.54 TON=1u
Iload vout 0 3
.op
.control
set noaskquit
op
let vdrop = v(vin)-v(vout)
let pd = vdrop*3
let dt = pd*74.6
print vdrop pd dt
quit
.endc
.end
