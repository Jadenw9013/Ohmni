B3 volt-second saturation of the magnetizing branch (XFMR_SAT, secondary open)
* lambda_pk = Vpk/(2*pi*f) = 200/(2 pi 50) = 0.63662 Wb ; expected peak magnetizing current from
* lambda(i) = LR*Lm*i + (1-LR)*Lm*ia*tanh(i/ia), Lm=LP-LLK, ia = ISATM/atanh(sqrt(DROP/(1-LR))) -> solved numerically (python bisect, shown in report)
* Linear (no-saturation) prediction would be lambda_pk/Lm = 0.6366 A. UIC is required: at t=0 the cosine source is at its peak and the DC operating point would short the inductor.
.include xfmr.lib
V1 in 0 SIN(0 200 50 0 0 90)
X1 in 0 s1 0 XFMR_SAT LP=1 N=1 LLK=1u RP=1m RS=1m CIW=1p ISATM=0.5 DROP=0.3 LR=0.05
RL s1 0 1G
.tran 20u 60m uic
.control
run
meas tran ipk max i(V1) from=10m to=50m
meas tran ipk2 min i(V1) from=10m to=50m
quit
.endc
.end
