* B2: voltage-drive of a power LED (3.00 V source + 0.1 ohm) with the same electro-thermal iteration; shows why a current source is required:
* the same 0.7 A-class operating point drifts up with temperature (negative tempco => current grows). Rth_total 39 K/W, eta=0.30 (ASSUMPTIONs).
.include models.inc
V1 vs 0 DC 3.0
R1 vs a 0.1
D1 a 0 LED_XPE2
.control
let tj = 25
let k = 0
let ilist = unitvec(8)
while k < 8
  option temp = $&tj
  op
  let i = (3.0 - v(a))/0.1
  let ilist[k] = i
  let vf = v(a)
  let tj = 25 + 39*(1-0.30)*vf*i
  let k = k + 1
end
print ilist
print tj
.endc
.end
