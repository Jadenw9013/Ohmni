* B1 BEH-CON-RF 50 ohm line terminated in 100 ohm: |Gamma|=1/3, VSWR=2, RL=9.542 dB (frequency independent for lossless line)
* v2: scalars vswr_3g (VSWR at 3 GHz), mag_3g printed; vector prints removed
Vs src 0 DC 0 AC 1
Rs src a 50
T1 a 0 b 0 Z0=50 TD=100p
RL b 0 100
.control
ac lin 3 1g 5g
let zin = v(a)/((v(src)-v(a))/50)
let gam = (zin-50)/(zin+50)
let mag = mag(gam)
let vswr = (1+mag)/(1-mag)
let rl = -20*log10(mag)
let vswr_3g = mag(vswr[1])
let mag_3g = mag[1]
let rl_3g = rl[1]
print vswr_3g mag_3g rl_3g
.endc
.end
