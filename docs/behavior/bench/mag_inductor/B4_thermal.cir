B4 self-heating steady state, XAL4020-222ME: DCR typ 35.2 mohm, Irms(40C rise)=5.5 A
* v2: RESULT echo replaced by scalar prints ind4_dt_5p5a, ind4_dt_2p75a, ind4_dt_6p6a (circuit unchanged)
* RTH = 40/(Irms^2*DCR*(1+TC*40)) = 32.4626 degC/W (DERIVED, assumes datasheet DCR is at 25C and rating test is self-consistent)
* Expected rise: dT = a/(1-a*TC), a = RTH*I^2*DCR : 40.0 @5.5A, 8.945 @2.75A, 61.88 @6.6A
.include ind_sat.lib
I1 0 p DC 5.5
X1 p 0 th IND_SAT_TH L0=2.2u Isat=5.6 DROP=0.3 LR=0.05 RDC=35.2m CP=0.01p RP=1e12 RTH=32.4626 CTH=0.05 TC=3.93m
.control
foreach ik 5.5 2.75 6.6
 alter I1 dc = $ik
 op
 if $ik eq 5.5
  let ind4_dt_5p5a = v(th)
  print ind4_dt_5p5a
 end
 if $ik eq 2.75
  let ind4_dt_2p75a = v(th)
  print ind4_dt_2p75a
 end
 if $ik eq 6.6
  let ind4_dt_6p6a = v(th)
  print ind4_dt_6p6a
 end
end
quit
.endc
.end
