* BEH-IC-LOGIC-SEQ B2: 74HC138 decoder, Vcc=4.5 V. Address 0..7 with G1=1,G2A=G2B=0 -> exactly one low output (Y[addr]=0, others 4.5 V).
* v2: added decoder_err accumulator (sum over addresses of |low_index-addr| + |nlow-1|) printed as 'name = value'; enable checks printed as scalars; decoding behavior unchanged
* Enable checks: G1=0 -> all high (y0 sampled 4.5 V at addr 7... all high); at 1990 ns G1=1,G2A=0,addr 7 -> y7 low; at 2190 ns G2A=1 -> y7 high.  Samples taken after 100 ns settling per step (step = 200 ns).
.include hc_seq.lib
Vcc vcc 0 4.5
Va a 0 pwl(0 0 200n 0 202n 4.5 400n 4.5 402n 0 600n 0 602n 4.5 800n 4.5 802n 0 1000n 0 1002n 4.5 1200n 4.5 1202n 0 1400n 0 1402n 4.5 1600n 4.5)
Vb b 0 pwl(0 0 400n 0 402n 4.5 800n 4.5 802n 0 1200n 0 1202n 4.5 1600n 4.5)
Vc c 0 pwl(0 0 800n 0 802n 4.5 1600n 4.5)
Vg1 g1 0 pwl(0 4.5 1600n 4.5 1602n 0 1800n 0 1802n 4.5)
Vg2a g2a 0 pwl(0 0 1800n 0 1802n 0 2000n 0 2002n 4.5)
Vg2b g2b 0 0
X1 a b c g2a g2b g1 y7 0 y6 y5 y4 y3 y2 y1 y0 vcc hc138
Cl0 y0 0 10p
Cl1 y1 0 10p
Cl2 y2 0 10p
Cl3 y3 0 10p
Cl4 y4 0 10p
Cl5 y5 0 10p
Cl6 y6 0 10p
Cl7 y7 0 10p
.tran 1n 2200n
.control
set noaskquit
run
* step k (address k) sampled at t = 100n + 200n*k ... but Va toggles at 200n multiples: sample at 190n + 200n*k
let k = 0
let derr = 0
while k < 8
  let t = 190n + 200n*k
  meas tran m0 find v(y0) at=$&t
  meas tran m1 find v(y1) at=$&t
  meas tran m2 find v(y2) at=$&t
  meas tran m3 find v(y3) at=$&t
  meas tran m4 find v(y4) at=$&t
  meas tran m5 find v(y5) at=$&t
  meas tran m6 find v(y6) at=$&t
  meas tran m7 find v(y7) at=$&t
  let s = m0+m1+m2+m3+m4+m5+m6+m7
  let idx = ((4.5-m1)+2*(4.5-m2)+3*(4.5-m3)+4*(4.5-m4)+5*(4.5-m5)+6*(4.5-m6)+7*(4.5-m7))/4.5
  let nlow = 8-s/4.5
  let derr = derr + abs(idx-k) + abs(nlow-1)
  echo addr $&k low_index=$&idx nlow=$&nlow
  let k = k + 1
end
meas tran e1 find v(y0) at=1790n
meas tran e2 find v(y7) at=1990n
meas tran e3 find v(y7) at=2190n
* decoder_err = sum over addresses 0..7 of |low_index-address| + |number_of_low_outputs-1| ; expected exactly 0 (to rail-leakage 1e-9)
echo decoder_err = $&derr
echo g1low_y0_v = $&e1
echo addr7_enabled_y7_v = $&e2
echo g2ahigh_y7_v = $&e3
quit
.endc
.end
