* BEH-TRN-BJT B4: Vce(sat)/Vbe(sat) of the fits against datasheet limits
* 2N3904 (2N3903/D Rev 9): Ic=10mA/Ib=1mA Vce(sat)<=0.2 V, Vbe(sat) 0.65-0.85 V ; Ic=50mA/Ib=5mA Vce(sat)<=0.3 V, Vbe(sat) 0.85-0.95 V
* PN2222A (PN2222A/D Rev 1.1.0): Ic=150mA/Ib=15mA (Ib ASSUMED, standard forced beta 10) Vce(sat)<=0.3 V, Vbe(sat) 0.6-1.2 V
* Expected: each value inside its limit. Tolerance: hard limit.
.include /home/claude/behavior/bench/trn_bjt/models_bjt_r6fit.lib
Q1 c1 b1 0 Q2N3904_R6FIT
Ic1 0 c1 10m
Ib1 0 b1 1m
Q2 c2 b2 0 Q2N3904_R6FIT
Ic2 0 c2 50m
Ib2 0 b2 5m
Q3 c3 b3 0 Q2N2222A_R6FIT
Ic3 0 c3 150m
Ib3 0 b3 15m
.control
set noaskquit
op
print v(c1) v(b1) v(c2) v(b2) v(c3) v(b3)
quit
.endc
.end
