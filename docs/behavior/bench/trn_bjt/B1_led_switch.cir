* BEH-TRN-BJT B1: 2N3904 saturated switch driving an LED
* 3.3 V logic -> Rb 1k -> base; collector: 5 V -> LED -> 220 ohm -> collector
* Analytic: Ic = (Vcc - Vf - Vce_sat)/R with Vf from diode eq. Vf=N*Vt*ln(Ic/Is)
*   N=2, Is=1e-19, Vt(27C)=0.025865  => Vf(13 mA)~2.03 V ; Vce(sat)~0.06 V (fit)
*   Ic_expected = (5-2.03-0.06)/220 = 13.2 mA  (tolerance 5 %)
*   forced beta = Ic/Ib ; Ib=(3.3-0.75)/1k=2.55 mA -> beta_forced ~5 (hard saturation)
.include /home/claude/behavior/bench/trn_bjt/models_bjt_r6fit.lib
.model LEDR D(IS=1e-19 N=2)
Vlogic in 0 3.3
Rb in b 1k
Q1 c b 0 Q2N3904_R6FIT
Vcc vcc 0 5
D1 vcc x LEDR
R1 x c 220
.control
set noaskquit
op
let ic = (v(x)-v(c))/220
print ic v(c) i(Vlogic)
quit
.endc
.end
