* BEH-REG-LINEAR B5: output-capacitor ESR / capacitance stability window of the behavioural loop (ILOAD step 0.40 -> 0.50 A)
* v2: absolute include path made relative; added scalars late_k_v (late peak, V) and ring3_ratio (late/early excess over settled value, case 3); circuit unchanged
* The loop: T(s) = GM*H(s)*Zout(s), H = 2-pole lag (FP1=200k, FP2=2M), Zout = Cout+ESR (resistive load). Analytic (small signal):
*   no ESR: |T|=1 at fu = GM/(2*pi*C): C=22u -> 289 kHz ; C=2.2u -> 2.9 MHz ; phase = -90 - atan(fu/FP1) - atan(fu/FP2)
*   C=22u: -90-55.3-8.2 = -153 deg -> PM 27 deg (stable, rings) ; C=2.2u: fu(est)~2.9 MHz : -90-86-55 = -231 deg -> unstable
*   an ESR zero at 1/(2*pi*ESR*C) adds up to +90 deg lead (ESR=0.3, C=22u: zero at 24 kHz) -> stable
* Expected (qualitative; GM/FP1/FP2 are ASSUMPTIONS, NOT datasheet values): cases 1, 2, 4 settle (late peak = final value 3.297 V); case 3 (2.2 uF, ESR 10 mohm) sustains an oscillation (late peak ~ early peak)
.include reg_behavioural_r6.lib
Vin vin 0 5
X1 vin v1 0 LDO_R6 VNOM=3.3 ROUTDC=0.006 GM=40 FP1=200k FP2=2meg
X2 vin v2 0 LDO_R6 VNOM=3.3 ROUTDC=0.006 GM=40 FP1=200k FP2=2meg
X3 vin v3 0 LDO_R6 VNOM=3.3 ROUTDC=0.006 GM=40 FP1=200k FP2=2meg
X4 vin v4 0 LDO_R6 VNOM=3.3 ROUTDC=0.006 GM=40 FP1=200k FP2=2meg
I1 v1 0 pwl(0 0.4 10u 0.4 10.1u 0.5 200u 0.5)
I2 v2 0 pwl(0 0.4 10u 0.4 10.1u 0.5 200u 0.5)
I3 v3 0 pwl(0 0.4 10u 0.4 10.1u 0.5 200u 0.5)
I4 v4 0 pwl(0 0.4 10u 0.4 10.1u 0.5 200u 0.5)
C1 v1 e1 22u
R1e e1 0 0.3
C2 v2 e2 22u
R2e e2 0 0.01
C3 v3 e3 2.2u
R3e e3 0 0.01
C4 v4 e4 2.2u
R4e e4 0 0.3
.nodeset v(v1)=3.3 v(v2)=3.3 v(v3)=3.3 v(v4)=3.3
.tran 0.02u 200u
.control
set noaskquit
run
meas tran a1_early max v(v1) from=10.1u to=40u
meas tran a1_late max v(v1) from=150u to=200u
meas tran a2_early max v(v2) from=10.1u to=40u
meas tran a2_late max v(v2) from=150u to=200u
meas tran a3_early max v(v3) from=10.1u to=40u
meas tran a3_late max v(v3) from=150u to=200u
meas tran a4_early max v(v4) from=10.1u to=40u
meas tran a4_late max v(v4) from=150u to=200u
let late1_v = a1_late
let late2_v = a2_late
let late3_v = a3_late
let late4_v = a4_late
let ring3_ratio = (a3_late-3.297)/(a3_early-3.297)
print late1_v late2_v late3_v late4_v ring3_ratio
quit
.endc
.end
