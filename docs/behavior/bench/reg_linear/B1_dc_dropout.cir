* BEH-REG-LINEAR B1: dropout of AMS1117-3.3 behavioural model at 0.8 A. Datasheet (Advanced Monolithic Systems DS1117): dropout 1.1 V typ / 1.3 V max at 800 mA
* v2: absolute include path made relative; the two op prints (same name v(vout), dropped as duplicates) replaced by vout_3p8v and vout_6v
* Parameters: VNOM=3.3 VDO=1.1 IDO=0.8.  Analytic: deep dropout Vout = Vin - Rdo*Iout = Vin - 1.1 (Rdo = 1.375 ohm).
* Expected: Vout(Vin=3.8) = 2.70 V, tolerance 3 %; Vout(Vin=6) = 3.3 + 0.0005*(6-5) - 0.006*0.8 = 3.2957 V (line reg 0.5 mV/V; load-reg resistance 6 mohm), tolerance 0.3 %
.include reg_behavioural_r6.lib
Vin vin 0 3.8
X1 vin vout 0 LDO_R6 VNOM=3.3 VINREF=5 KLINE=0.0005 ROUTDC=0.006 VDO=1.1 IDO=0.8 IQ=5m ILIM=1.2 GM=200 FP1=300k FP2=1meg RTH=61.6
Iload vout 0 0.8
Cout vout 0 22u
.nodeset v(vout)=3.3
.control
set noaskquit
op
let vout_3p8v = v(vout)
print vout_3p8v
alter Vin = 6
op
let vout_6v = v(vout)
print vout_6v
quit
.endc
.end
