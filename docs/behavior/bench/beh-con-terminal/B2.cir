* B2 terminal thermal rise with R(T) feedback and runaway threshold.
* R0=3 mohm (ASSUMPTION), Rth chosen so 30 K rise at 12 A (ASSUMPTION), alpha=0.0039/K
.param R0=3m alpha=0.0039 Irat=12
.param Rth={30/(Irat**2*R0)}
.param Ia=12
Bdt dt 0 V = ({Ia}**2*{R0}*{Rth})/(1-{Ia}**2*{R0}*{alpha}*{Rth})
Rd dt 0 1G
Bir ir 0 V = 1/sqrt({R0}*{alpha}*{Rth})
Rr ir 0 1G
.control
op
print v(dt) v(ir)
let e1 = 30/(1-144*0.003*0.0039*(30/(144*0.003)))
let e2 = 1/sqrt(0.003*0.0039*(30/(144*0.003)))
print e1 e2
quit
.endc
.end
