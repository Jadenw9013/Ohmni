B2 Film capacitor self-resonance with lead ESL: f0 = 1/(2 pi sqrt(ESL*C))
* C=1u, ESL=15n (ASSUMED lead/body inductance, see doc) -> f0 = 1.2995 MHz
.include ohm_film.lib
Iac 0 p dc 0 ac 1
Rb p 0 1e12
Xc p 0 f ohm_film C0=1u TAND=20e-4 FREF=1k ESL=15n RLK=1e15
Rf f 0 1meg
.ac dec 400 10k 100meg
.control
run
let zm = vm(p)
meas ac zmin min zm
quit
.endc
.end
