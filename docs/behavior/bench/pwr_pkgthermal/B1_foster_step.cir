* BEH-PWR-PKGTHERMAL B1: two-stage Foster thermal network step response, IRFZ44N-style TO-220 (RthJC 1.5, RthCS 0.5 greased, RthSA = 60 -> RthJA 62 as in the datasheet)
* v2: removed print of meas results (duplicate names dropped by audit); tj_inf_c = Tj at t=399 s; circuit unchanged
* Network: P (A-equivalent current source, 1 W = 1 A) into node tj; R1=1.5 (j-c) with C1 (die/lead frame); node tc; R2 = 60.5 (c-a) with C2 (tab+copper/sink); ambient 25 V
* C1 = 0.02 J/K, C2 = 0.5 J/K are ASSUMPTIONS (no datasheet transient Zth curve was captured), so only the DC value is checked quantitatively.
* P = 2 W:  Tj(inf) = 25 + 2*(1.5+60.5) = 149.0 C  (analytic, tolerance 0.5 %).
.options method=gear
Ip 0 tj dc 2
R1 tj tc 1.5
C1 tj 0 0.02 ic=25
R2 tc ta 60.5
C2 tc 0 0.5 ic=25
Vta ta 0 25
.tran 10m 400 uic
.control
set noaskquit
run
meas tran tj_end find v(tj) at=399
meas tran tj_1s find v(tj) at=1
let tj_inf_c = tj_end
print tj_inf_c
quit
.endc
.end
